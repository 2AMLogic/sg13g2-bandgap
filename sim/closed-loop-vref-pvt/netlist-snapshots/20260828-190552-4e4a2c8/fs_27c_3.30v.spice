* sg13g2-bandgap -- bandgap_core + bandgap_amp + bandgap_startup
* co-simulated closed-loop DC/vref characterization testbench (issue #86,
* follow-on to #58). Generated from
* sim/closed-loop-vref-pvt/testbench/tb_closed_loop_vref.spice.tmpl
* by sim/closed-loop-vref-pvt/run_pvt_sweep.sh -- do not edit a generated
* netlist-snapshots/*.spice file directly, edit this template and re-run
* the sweep. Full rationale is in sim/closed-loop-vref-pvt/README.md.
*
* Generated for: corner=fs temp=27C vdd=3.30V
* DUT git sha (design/netlist/bandgap_core.spice,
* design/netlist/bandgap_amp.spice and design/netlist/bandgap_startup.spice
* this was copied from):
*   core=4832c71 amp=397fe2d startup=66ac99d
* PDK: ihp-sg13g2 /home/ubuntu/share/pdk (see sim/pdk.json for the pinned release)
* OSDI models: /home/ubuntu/share/pdk/ihp-sg13g2/libs.tech/ngspice/osdi (built by sim/tools/build-osdi.sh)
*
* This is the SAME co-simulated topology sim/closed-loop-startup/ uses
* (all three DUTs copied verbatim, wired exactly as design/bandgap_top.sch
* specifies -- see that experiment's own template header for the full
* device-copy rationale, not repeated here) -- but this testbench's own
* claim is different: not "does it start and close the loop" (already
* proven, sim/closed-loop-startup, 45/45 PASS), but "what DC value does
* vref actually settle to, and how steady is it" -- the input this
* experiment's own TC (temperature coefficient) computation needs. The vdd
* ramp is held to 3 ms here (vs 2 ms in sim/closed-loop-startup) and vref
* is measured at BOTH t=2ms and t=3ms so run_pvt_sweep.sh can confirm the
* value has genuinely stopped moving (a real DC operating point, not a
* still-slewing transient snapshot) before reporting it as this
* experiment's headline number. Issue #133 added a second measured
* quantity, VBE(Q3) (v(cb3), same two time points, same settledness
* rationale) -- decision-support evidence for the #128 Output-reference
* escalation, which traced the untrimmed vref accuracy gap to an
* unverified VBE(Q3)~=0.75V sizing assumption in design/bandgap_core.sch.

.lib "/home/ubuntu/share/pdk/ihp-sg13g2/libs.tech/ngspice/models/cornerHBT.lib" hbt_typ
.lib "/home/ubuntu/share/pdk/ihp-sg13g2/libs.tech/ngspice/models/cornerMOShv.lib" mos_fs
.lib "/home/ubuntu/share/pdk/ihp-sg13g2/libs.tech/ngspice/models/cornerRES.lib" res_typ

* rshunt=1e9 / gmin=1e-9: the same convergence aids sim/closed-loop-startup
* needed at a handful of PVT corners during the very early (sub-1V) part of
* the vdd ramp, where bandgap_core's diode-connected npn13G2 legs sit at a
* genuinely near-singular, near-zero-bias operating point before any real
* current has been established -- see that experiment's README "A real
* numerical finding" section for the full whack-a-mole derivation of this
* exact pair of values. This testbench drives the same three DUTs through
* the same kind of ramp, so it inherits the same numerical stiffness at the
* same early instant and needs the same aids.
.options temp=27 tnom=27 rshunt=1e9 gmin=1e-9

* FIXTURE -- transient supply ramp: vdd ramps 0 -> VDD over 200 us (same
* rise sim/closed-loop-startup and sim/startup-core-handover use) and holds
* to 3 ms (1 ms longer than sim/closed-loop-startup's 2 ms hold) so this
* testbench can measure vref at two separated time points (2 ms and 3 ms)
* and confirm it has stopped moving between them before trusting it as a
* DC value.
Vvdd vdd 0 PWL(0 0 200u 3.30 3m 3.30)
Vvss vss 0 dc 0
* both bandgap_core.spice and bandgap_amp.spice wire their resistor bulk
* terminals (rppd inside the core) to the global substrate net `sub!`,
* the same convention every testbench in this tree uses.
Vsub sub! vss dc 0

* DUT -- design/netlist/bandgap_core.spice, verbatim.
XM1 sns1 fb vdd vdd sg13_hv_pmos w=10u l=1u ng=1 m=1
XQ1 sns1 sns1 vss vss npn13G2 Nx=1
XM2 sns2 fb vdd vdd sg13_hv_pmos w=10u l=1u ng=1 m=1
XR2 sns2 cb2 sub! rppd w=2u l=82.7u m=1 b=0
XQ2 cb2 cb2 vss vss npn13G2 Nx=8
XM3 vref fb vdd vdd sg13_hv_pmos w=10u l=1u ng=1 m=1
XR1 vref cb3 sub! rppd w=2u l=694.5u m=1 b=0
XQ3 cb3 cb3 vss vss npn13G2 Nx=1

* DUT -- design/netlist/bandgap_amp.spice, verbatim. in_p <- sns2
* (non-inverting), in_n <- sns1 (inverting), out -> fb -- see
* design/bandgap_amp.sch's own header "polarity" section for the
* derivation of which sense node is which input.
XMTAIL tail fb vdd vdd sg13_hv_pmos w=10u l=1u ng=1 m=1
XMP1 d1 sns2 tail vdd sg13_hv_pmos w=20u l=1u ng=1 m=1
XMP2 d2 sns1 tail vdd sg13_hv_pmos w=20u l=1u ng=1 m=1
XMP3 pn pn vdd vdd sg13_hv_pmos w=10u l=1u ng=1 m=1
XMP4 fb pn vdd vdd sg13_hv_pmos w=10u l=1u ng=1 m=1
XMN1 d1 d1 vss vss sg13_hv_nmos w=10u l=1u ng=1 m=1
XMN2 d2 d2 vss vss sg13_hv_nmos w=10u l=1u ng=1 m=1
XMN3 fb d1 vss vss sg13_hv_nmos w=10u l=1u ng=1 m=1
XMN4 pn d2 vss vss sg13_hv_nmos w=10u l=1u ng=1 m=1

* DUT -- design/netlist/bandgap_startup.spice, verbatim. `sns1` and `fb`
* are shared with the core and amp DUTs above -- the nodes the assembled
* block actually connects. No separate stimulus source drives either one.
*
* FIXTURE -- Vmkfb is a 0 V ammeter in series with XMKFB's drain, so the
* startup circuit's own contribution to the shared fb node can be measured
* directly (i_mkfb below) rather than inferred from fb's voltage alone. A
* 0 V source is a DC/transient short and does not move the operating point.
XRPU vdd det sub! rhigh w=1u l=1411.3u m=1 b=0
XMSENSE det sns1 vss vss sg13_hv_nmos w=10u l=0.5u ng=1 m=1
Vmkfb fb fbx dc 0
XMKFB fbx det vss vss sg13_hv_nmos w=2u l=0.5u ng=1 m=1

.control
pre_osdi /home/ubuntu/share/pdk/ihp-sg13g2/libs.tech/ngspice/osdi/psp103.osdi
pre_osdi /home/ubuntu/share/pdk/ihp-sg13g2/libs.tech/ngspice/osdi/psp103_nqs.osdi
pre_osdi /home/ubuntu/share/pdk/ihp-sg13g2/libs.tech/ngspice/osdi/mosvar.osdi
pre_osdi /home/ubuntu/share/pdk/ihp-sg13g2/libs.tech/ngspice/osdi/r3_cmc.osdi
tran 2u 3m
* Loop-closure / startup-release sanity (same criteria/sense as
* sim/closed-loop-startup, evaluated here at t=3ms instead of 2ms) --
* prerequisite for trusting the vref reading below as a real closed-loop
* operating point rather than a still-starting or railed transient.
meas tran v_fb_v find v(fb) at=3m
meas tran v_sns1_v find v(sns1) at=3m
meas tran v_sns2_v find v(sns2) at=3m
meas tran v_det_v find v(det) at=3m
meas tran i_mkfb_v find i(Vmkfb) at=3m
* The claim under test: vref at two separated time points, so
* run_pvt_sweep.sh can confirm it has stopped moving (a real DC value, not
* a still-slewing snapshot) before reporting it.
meas tran v_vref_2ms find v(vref) at=2m
meas tran v_vref_3ms find v(vref) at=3m
* VBE(Q3) (issue #133, decision-support for the #128 Output-reference
* escalation): Q3 is diode-connected (XQ3 cb3 cb3 vss vss npn13G2 Nx=1)
* with its emitter tied to vss (the 0 V reference), so v(cb3) IS VBE(Q3)
* directly -- no subtraction needed. design/bandgap_core.sch's own header
* derives R1 from an ASSUMED VBE(Q3)~=0.75V that was never simulated; this
* measures the real value at the same two time points as vref above, so
* run_pvt_sweep.sh can confirm it too has settled before reporting it.
meas tran v_vbeq3_2ms find v(cb3) at=2m
meas tran v_vbeq3_3ms find v(cb3) at=3m
.endc
.end
