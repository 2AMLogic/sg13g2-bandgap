* sg13g2-bandgap -- SG13CMOS5L bandgap_startup PVT testbench (issue #65)
* Generated from
* sim/sg13cmos5l-startup-trip-point/testbench/tb_sg13cmos5l_startup_trip_point.spice.tmpl
* by sim/sg13cmos5l-startup-trip-point/run_pvt_sweep.sh -- do not edit a
* generated netlist-snapshots/*.spice file directly, edit this template and
* re-run the sweep. Full rationale is in
* sim/sg13cmos5l-startup-trip-point/README.md.
*
* Generated for: corner=bcs temp=27C vdd=3.63V
* DUT git sha (design/sg13cmos5l/netlist/bandgap_startup.spice this was
* copied from):
*   8361d0d
* PDK: ihp-sg13cmos5l /home/ubuntu/share/pdk (see sim/pdk-sg13cmos5l.json for the pinned
*   revision)
* OSDI models: /home/ubuntu/share/pdk/ihp-sg13cmos5l/libs.tech/ngspice/osdi (this PDK ships these prebuilt -- see
*   sim/pdk-sg13cmos5l.json "osdi_toolchain")
*
* design/sg13cmos5l/bandgap_startup.sch (issue #68) is a direct port of
* SG13G2's own design/bandgap_startup.sch with only the symbol-library path
* changed -- same device sizes, same topology, no bipolar device at all (see
* design/sg13cmos5l/README.md "issue #68" section). All three DUT devices
* below are copied verbatim from design/sg13cmos5l/netlist/bandgap_startup.spice:
* same instance names, same node names, same W/L.

.lib "/home/ubuntu/share/pdk/ihp-sg13cmos5l/libs.tech/ngspice/models/cornerMOShv.lib" mos_ff
.lib "/home/ubuntu/share/pdk/ihp-sg13cmos5l/libs.tech/ngspice/models/cornerRES.lib" res_bcs

.options temp=27 tnom=27

Vvdd vdd 0 dc 3.63
Vvss vss 0 dc 0
* bandgap_startup.spice wires the rhigh bulk terminal to the global
* substrate net `sub!`; tied to vss through a 0 V source here, as in
* sim/sg13cmos5l-core-open-loop-bias and every SG13G2 testbench in this tree.
Vsub sub! vss dc 0

* FIXTURE 1 -- sns1 stimulus. In the assembled block, sns1 is the bandgap
* core's own sense node (bandgap_core.sch's XQ1 emitter -- see
* sim/sg13cmos5l-core-open-loop-bias/README.md for the grounded-collector
* topology this differs from SG13G2's grounded-emitter core). Here it is
* driven by a source so the startup circuit's response can be swept from
* "core is dead" (sns1 = 0) to "core is up" (sns1 = vdd) in one analysis --
* same fixture pattern sim/startup-trip-point uses for the SG13G2 startup
* circuit.
Vsns1 sns1 vss dc 0

* FIXTURE 2 -- fb load. fb is the PMOS mirror gate; a real error amplifier
* (design/sg13cmos5l/bandgap_amp.sch, issue #68) exists for this core, but
* this testbench isolates the startup circuit's own behavior the same way
* sim/startup-trip-point does for SG13G2 -- see README.md. This 10 Mohm
* pull-up stands in for whatever eventually holds fb high, weak enough
* (<= 0.4 uA) that it does not contest XMKFB's pull-down.
Rfbpu vdd fb 10meg

XRPU vdd det sub! rhigh w=1u l=1411.3u m=1 b=0
XMSENSE det sns1 vss vss sg13_hv_nmos w=10u l=0.5u ng=1 m=1
XMKFB fb det vss vss sg13_hv_nmos w=2u l=0.5u ng=1 m=1

.control
pre_osdi /home/ubuntu/share/pdk/ihp-sg13cmos5l/libs.tech/ngspice/osdi/psp103.osdi
pre_osdi /home/ubuntu/share/pdk/ihp-sg13cmos5l/libs.tech/ngspice/osdi/psp103_nqs.osdi
pre_osdi /home/ubuntu/share/pdk/ihp-sg13cmos5l/libs.tech/ngspice/osdi/mosvar.osdi
pre_osdi /home/ubuntu/share/pdk/ihp-sg13cmos5l/libs.tech/ngspice/osdi/r3_cmc.osdi
* 1) cold-start state: core dead (sns1 = 0), startup must be engaged.
op
print v(det) v(fb)
* 2) disengage behaviour: sweep the core's sense node up and find where the
*    detect node releases, plus the fully-running-core end state.
dc Vsns1 0 3.63 0.005
meas dc vtrip when v(det)=1.8150 cross=1
meas dc det_off find v(det) at=3.5800
meas dc fb_off find v(fb) at=3.5800
.endc
.end
