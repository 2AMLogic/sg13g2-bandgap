* sg13g2-bandgap -- pre-trim, aids-removable box-method TC A/B testbench
* (issue #269). Generated from
* sim/closed-loop-vref-boxtc-pretrim-aidsfree/testbench/
* tb_closed_loop_vref_boxtc_pretrim_ab.spice.tmpl by
* sim/closed-loop-vref-boxtc-pretrim-aidsfree/run_ab_points.sh -- do not
* edit a generated netlist-snapshots/*.spice file directly, edit this
* template and re-run. Full rationale is in
* sim/closed-loop-vref-boxtc-pretrim-aidsfree/README.md.
*
* Generated for: corner=bcs temp=0C vdd=3.63V
* aids=aidsfree
* PDK: ihp-sg13g2 /home/ubuntu/share/pdk (see sim/pdk.json for the pinned release)
* OSDI models: /home/ubuntu/share/pdk/ihp-sg13g2/libs.tech/ngspice/osdi (built by sim/tools/build-osdi.sh)
*
* THIS IS A DELIBERATELY HISTORICAL DUT, not the current design/ netlist --
* issue #269's whole point is isolating the convergence-aid effect FROM the
* trim-ladder effect, so the core below is byte-for-byte the PRE-TRIM
* bandgap_core (monolithic XR1, no XXTRIM ladder) as it stood at git blob
* `d83f7c4`, i.e. the DUT
* sim/closed-loop-vref-pvt-boxtc/records/20260921-194249-77820fc* already
* measured aided, BEFORE issue #229 segmented R1 into the trim ladder and
* BEFORE issue #264 re-pointed every schematic-DUT bench (including that
* same closed-loop-vref-pvt-boxtc directory) at the trim-bearing core with
* the aids dropped. Because this netlist intentionally does not match
* today's design/netlist/bandgap_core.spice, this record's own D2
* freshness check (.github/scripts/check_evidence_formats.py) is expected
* to report "not checked" for it rather than compare device sets -- see
* this experiment's README "Why a historical DUT, and why D2 skips it".
*
* The ONLY axis this template varies beyond corner/temp/vdd is whether the
* rshunt=1e9/gmin=1e-9 convergence aids are present (aidsfree below;
*  is either "rshunt=1e9 gmin=1e-9 " or "" with nothing
* else on the .options line touched) -- every other device, fixture and
* .measure card is byte-identical to the historical aided record's own
* tb_closed_loop_vref_boxtc.spice.tmpl (git blob ebd0c02), which was itself
* byte-identical to sim/closed-loop-vref-pvt's own template from the .lib
* line down.

.lib "/home/ubuntu/share/pdk/ihp-sg13g2/libs.tech/ngspice/models/cornerHBT.lib" hbt_bcs
.lib "/home/ubuntu/share/pdk/ihp-sg13g2/libs.tech/ngspice/models/cornerMOShv.lib" mos_ff
.lib "/home/ubuntu/share/pdk/ihp-sg13g2/libs.tech/ngspice/models/cornerRES.lib" res_bcs

* SOLVER OPTIONS -- issue #269's one deliberate axis. reltol=5e-3 (#149) is
* always kept; rshunt=1e9/gmin=1e-9 (the pre-trim bench's own convergence
* aids) are present only when aidsfree=aided.
.options temp=0 tnom=27 reltol=5e-3

* FIXTURE -- transient supply ramp, byte-identical to the historical
* pre-trim template: vdd ramps 0 -> VDD over 200 us and holds to 3 ms.
Vvdd vdd 0 PWL(0 0 200u 3.63 3m 3.63)
Vvss vss 0 dc 0
Vsub sub! vss dc 0

* DUT -- design/netlist/bandgap_core.spice as it stood at git blob
* d83f7c4 (pre-#229, monolithic XR1 l=511u, no trim ladder).
XM1 sns1 fb vdd vdd sg13_hv_pmos w=10u l=1u ng=1 m=1
XQ1 sns1 sns1 vss vss npn13G2 Nx=1
XM2A sns2 fb vdd vdd sg13_hv_pmos w=9u l=1u ng=1 m=1
XM2B sns2 fb vdd vdd sg13_hv_pmos w=1u l=1u ng=1 m=1
XR2 sns2 cb2 sub! rppd w=2u l=82.7u m=1 b=0
XQ2 cb2 cb2 vss vss npn13G2 Nx=8
XM3A vref fb vdd vdd sg13_hv_pmos w=8u l=1u ng=1 m=1
XM3B vref fb vdd vdd sg13_hv_pmos w=1u l=1u ng=1 m=1
XM3C vref fb vdd vdd sg13_hv_pmos w=1u l=1u ng=1 m=1
XR1 vref cb3 sub! rppd w=2u l=511u m=1 b=0
XQ3 cb3 cb3 vss vss npn13G2 Nx=1

* DUT -- design/netlist/bandgap_amp.spice, verbatim (unchanged by #229).
XMTAIL tail fb vdd vdd sg13_hv_pmos w=10u l=1u ng=1 m=1
XMP1 d1 sns2 tail vdd sg13_hv_pmos w=20u l=1u ng=1 m=1
XMP2 d2 sns1 tail vdd sg13_hv_pmos w=20u l=1u ng=1 m=1
XMP3 pn pn vdd vdd sg13_hv_pmos w=10u l=1u ng=1 m=1
XMP4 fb pn vdd vdd sg13_hv_pmos w=10u l=1u ng=1 m=1
XMN1 d1 d1 vss vss sg13_hv_nmos w=10u l=1u ng=1 m=1
XMN2 d2 d2 vss vss sg13_hv_nmos w=10u l=1u ng=1 m=1
XMN3 fb d1 vss vss sg13_hv_nmos w=10u l=1u ng=1 m=1
XMN4 pn d2 vss vss sg13_hv_nmos w=10u l=1u ng=1 m=1

* DUT -- design/netlist/bandgap_startup.spice, verbatim (unchanged by #229).
XRPU vdd det sub! rhigh w=1u l=1411.3u m=1 b=0
XMSENSE det sns1 vss vss sg13_hv_nmos w=10u l=0.5u ng=1 m=1
Vmkfb fb fbx dc 0
XMKFB fbx det vss vss sg13_hv_nmos w=2u l=0.5u ng=1 m=1

.control
pre_osdi /home/ubuntu/share/pdk/ihp-sg13g2/libs.tech/ngspice/osdi/psp103.osdi
pre_osdi /home/ubuntu/share/pdk/ihp-sg13g2/libs.tech/ngspice/osdi/psp103_nqs.osdi
pre_osdi /home/ubuntu/share/pdk/ihp-sg13g2/libs.tech/ngspice/osdi/mosvar.osdi
pre_osdi /home/ubuntu/share/pdk/ihp-sg13g2/libs.tech/ngspice/osdi/r3_cmc.osdi
save v(vref) v(fb) v(sns1) v(sns2) v(det) v(cb3) v(vmkfb) i(Vmkfb)
tran 50n 3m
meas tran v_fb_v find v(fb) at=3m
meas tran v_sns1_v find v(sns1) at=3m
meas tran v_sns2_v find v(sns2) at=3m
meas tran v_det_v find v(det) at=3m
meas tran i_mkfb_v find i(Vmkfb) at=3m
meas tran v_vref_2ms find v(vref) at=2m
meas tran v_vref_3ms find v(vref) at=3m
meas tran v_vbeq3_2ms find v(cb3) at=2m
meas tran v_vbeq3_3ms find v(cb3) at=3m
.endc
.end
