* sg13g2-bandgap -- bandgap_core + bandgap_amp + bandgap_startup
* closed-loop untrimmed vref MISMATCH MONTE CARLO testbench (issue #215,
* T1 tracker #4 item 6 evidence, follow-on to #86/#88). Generated from
* sim/closed-loop-vref-mc/testbench/tb_closed_loop_vref_mc.spice.tmpl by
* sim/closed-loop-vref-mc/run_mc.sh -- do not edit a generated
* netlist-snapshots/*.spice file directly, edit this template and re-run
* the campaign. Full methodology rationale is in
* sim/closed-loop-vref-mc/README.md.
*
* Generated for: point=negctrl mode=negctrl
* corner=typ temp=27C vdd=3.30V draw=0
* rndseed=20260909
* DUT git sha (design/netlist/bandgap_core.spice,
* design/netlist/bandgap_amp.spice and design/netlist/bandgap_startup.spice
* this was copied from):
*   core=d83f7c4 amp=397fe2d startup=66ac99d seeds=20260830-132425-d83f7c4.csv@94207b4
* PDK: ihp-sg13g2 /Users/rwalters/share/pdk (see sim/pdk.json for the pinned release)
* OSDI models: /Users/rwalters/share/pdk/ihp-sg13g2/libs.tech/ngspice/osdi (built by sim/tools/build-osdi.sh)
*
* ------------------------------------------------------------- MC method
* This is the SAME co-simulated closed-loop topology
* sim/closed-loop-vref-pvt/ and sim/closed-loop-offset/ both use (all three
* DUTs copied verbatim, wired exactly as design/bandgap_top.sch specifies,
* loop NOT broken, no offset probe here -- unlike closed-loop-offset's
* deterministic Vos sensitivity probe, this testbench draws a RANDOM device
* mismatch sample per run). Two ingredients make one draw:
*   1. `.options rndseed=20260909` -- placed at SPICE-netlist level, BEFORE
*      any `.lib`/device is parsed, NOT inside `.control`. Verified by
*      direct experiment (not assumed): ngspice's mismatch-model `agauss()`
*      expressions are evaluated once, at netlist-parse time, so a `set
*      rndseed=N` issued later from inside `.control` (after parsing has
*      already happened) has NO effect on them -- confirmed by two separate
*      `.control`-only-seeded runs of the same netlist producing DIFFERENT
*      draws. `.options rndseed=N` at the top level, by contrast, is read
*      before parsing and reproduces bit-for-bit across separate ngspice
*      invocations with the same seed (also verified directly).
*   2. The `_mismatch` corner-lib sections (`hbt_typ_mismatch`,
*      `mos_tt_mismatch`, `res_typ_mismatch`, and their bcs/wcs siblings) --
*      SG13G2's per-device `agauss()`-based statistical variation models,
*      as opposed to the plain (`hbt_typ`, `mos_tt`, `res_typ`, ...)
*      deterministic sections every PVT-sweep testbench in this tree uses.
*      The NEGATIVE CONTROL runs of this same template select the plain
*      (non-`_mismatch`) sections instead -- with `.options rndseed=20260909`
*      still varying draw to draw, so that run demonstrates (not just
*      assumes) that varying the seed against non-statistical models
*      produces EXACTLY ZERO spread, the way sky130-sar-adc/sim/mc-smoke/
*      does for its own negative control.
*
* ------------------------------------------------------- DC bias: nodeset
* Same .nodeset-seeding technique sim/closed-loop-offset/,
* sim/loop-gain-phase-margin/ and sim/closed-loop-psrr/ all use, and for the
* same reason (this circuit has more than one DC equilibrium, and a bare
* .op has no guaranteed way to land in the intended one) -- seeded from
* sim/closed-loop-startup's own committed per-corner converged transient
* endpoint for the REAL (nominal, non-mismatch) circuit at this same
* corner/temp/vdd. This is only a Newton-Raphson initial-guess HINT, not an
* enforced constraint: a real mismatch draw is expected to converge NEAR
* but not exactly AT this seed (that shift is the effect under test), and
* this testbench's own pass criteria (see run_mc.sh) do not gate on
* reproducing the seed, only on the loop still being genuinely closed
* around its own new equilibrium. Using a single DC .op per draw (instead
* of sim/closed-loop-vref-pvt's full startup-ramp transient) is what makes
* an N>=300-draw campaign tractable: empirically, .op here (with the OSDI
* models already resident) runs in a small fraction of a second of ngspice
* CPU time per draw, vs. tens of seconds for a full 3 ms startup-ramp
* transient at the same corner -- the difference between an
* O(minutes)-total campaign and an O(hours)-total one for the same N.
.nodeset v(fb)=2.49615e+00 v(sns1)=7.08270e-01 v(sns2)=7.08195e-01 v(vref)=1.04947e+00

.options rndseed=20260909

.lib "/Users/rwalters/share/pdk/ihp-sg13g2/libs.tech/ngspice/models/cornerHBT.lib" hbt_typ
.lib "/Users/rwalters/share/pdk/ihp-sg13g2/libs.tech/ngspice/models/cornerMOShv.lib" mos_tt
.lib "/Users/rwalters/share/pdk/ihp-sg13g2/libs.tech/ngspice/models/cornerRES.lib" res_typ

.options temp=27 tnom=27

* FIXTURE -- vdd is a fixed DC source (no ramp, no AC): this testbench
* measures a DC operating-point mismatch draw, not a startup transient.
Vvdd vdd 0 dc 3.30
Vvss vss 0 dc 0
Vsub sub! vss dc 0

* DUT -- design/netlist/bandgap_core.spice, verbatim (loop NOT broken). M2/M3
* decomposed into per-leg-distinct counts (1/2/3) of dominant-plus-trim-
* finger sg13_hv_pmos instances (issue #149 -- see
* sim/closed-loop-vref-pvt/testbench/tb_closed_loop_vref.spice.tmpl's own
* header for the fuller rationale, not repeated here).
XM1 sns1 fb vdd vdd sg13_hv_pmos w=10u l=1u ng=1 m=1
XQ1 sns1 sns1 vss vss npn13G2 Nx=1
XM2A sns2 fb vdd vdd sg13_hv_pmos w=9u l=1u ng=1 m=1
XM2B sns2 fb vdd vdd sg13_hv_pmos w=1u l=1u ng=1 m=1
XR2 sns2 cb2 sub! rppd w=2u l=82.7u m=1 b=0
XQ2 cb2 cb2 vss vss npn13G2 Nx=8
XM3A vref fb vdd vdd sg13_hv_pmos w=8u l=1u ng=1 m=1
XM3B vref fb vdd vdd sg13_hv_pmos w=1u l=1u ng=1 m=1
XM3C vref fb vdd vdd sg13_hv_pmos w=1u l=1u ng=1 m=1
XR1 vref cb3 sub! rppd w=2u l=511u m=1 b=0
XQ3 cb3 cb3 vss vss npn13G2 Nx=1

* DUT -- design/netlist/bandgap_amp.spice, verbatim. in_p <- sns2
* (non-inverting), in_n <- sns1 (inverting) -- unmodified topology, no
* offset probe (unlike sim/closed-loop-offset/'s own template).
XMTAIL tail fb vdd vdd sg13_hv_pmos w=10u l=1u ng=1 m=1
XMP1 d1 sns2 tail vdd sg13_hv_pmos w=20u l=1u ng=1 m=1
XMP2 d2 sns1 tail vdd sg13_hv_pmos w=20u l=1u ng=1 m=1
XMP3 pn pn vdd vdd sg13_hv_pmos w=10u l=1u ng=1 m=1
XMP4 fb pn vdd vdd sg13_hv_pmos w=10u l=1u ng=1 m=1
XMN1 d1 d1 vss vss sg13_hv_nmos w=10u l=1u ng=1 m=1
XMN2 d2 d2 vss vss sg13_hv_nmos w=10u l=1u ng=1 m=1
XMN3 fb d1 vss vss sg13_hv_nmos w=10u l=1u ng=1 m=1
XMN4 pn d2 vss vss sg13_hv_nmos w=10u l=1u ng=1 m=1

* DUT -- design/netlist/bandgap_startup.spice, verbatim. `sns1` and `fb`
* are shared with the core and amp DUTs above -- the nodes the assembled
* block actually connects.
*
* FIXTURE -- Vmkfb is a 0V ammeter in series with XMKFB's drain (same
* fixture every closed-loop experiment in this tree uses). A 0V source is
* a DC short and does not move the operating point.
XRPU vdd det sub! rhigh w=1u l=1411.3u m=1 b=0
XMSENSE det sns1 vss vss sg13_hv_nmos w=10u l=0.5u ng=1 m=1
Vmkfb fb fbx dc 0
XMKFB fbx det vss vss sg13_hv_nmos w=2u l=0.5u ng=1 m=1

.control
pre_osdi /Users/rwalters/share/pdk/ihp-sg13g2/libs.tech/ngspice/osdi/psp103.osdi
pre_osdi /Users/rwalters/share/pdk/ihp-sg13g2/libs.tech/ngspice/osdi/psp103_nqs.osdi
pre_osdi /Users/rwalters/share/pdk/ihp-sg13g2/libs.tech/ngspice/osdi/mosvar.osdi
pre_osdi /Users/rwalters/share/pdk/ihp-sg13g2/libs.tech/ngspice/osdi/r3_cmc.osdi
op
* Parsed by run_mc.sh from these exact "v(node) = value" / "i(vmkfb) =
* value" lines (ngspice has no ".meas op" analysis type -- "print" is this
* tree's standard way to pull a DC operating-point value out of a
* .control block, same convention sim/closed-loop-offset/ uses).
print v(fb)
print v(sns1)
print v(sns2)
print v(vref)
print v(det)
print i(Vmkfb)
.endc
.end
