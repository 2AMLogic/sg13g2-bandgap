* klt sim -- generated corner deck, do not edit
* --- inlined .include body.spice (klt_sim_evidence.py) ---
* klt sim netlist BODY rendered by sim/loop-gain-phase-margin/tools/klt_trim_axis.py
* (issue #271) from testbench/tb_loop_gain.spice.tmpl. Fixture-only changes vs the
* template: `.options temp=` dropped (klt sim emits `.temp`), the analysis
* `.control` block reduced to its pre_osdi lines, the OP PROBE fixture and a
* `.save` card added, `.end` dropped. DUT devices and the loop break: verbatim.
*
* sg13g2-bandgap -- bandgap_core + bandgap_amp + bandgap_startup
* closed-loop AC loop-gain / phase-margin testbench (issue #86, follow-on
* to #58). Generated from
* sim/loop-gain-phase-margin/testbench/tb_loop_gain.spice.tmpl
* by sim/loop-gain-phase-margin/run_pvt_sweep.sh -- do not edit a generated
* netlist-snapshots/*.spice file directly, edit this template and re-run
* the sweep. Full methodology rationale is in
* sim/loop-gain-phase-margin/README.md.
*
* Generated for: corner=wcs temp=-40C vdd=3.30V
* DUT git sha (design/netlist/bandgap_core.spice,
* design/netlist/bandgap_amp.spice and design/netlist/bandgap_startup.spice
* this was copied from):
*   core=9530863 amp=397fe2d startup=66ac99d seeds=20261001-083332-e5507b2.csv@4fe07ea
* PDK: ihp-sg13g2 ${PDK_ROOT} (see sim/pdk.json for the pinned release)
* OSDI models: ${PDK_ROOT}/ihp-sg13g2/libs.tech/ngspice/osdi (built by sim/tools/build-osdi.sh)
*
* --------------------------------------------------------- loop-break method
* Same three DUTs as sim/closed-loop-startup/ and sim/closed-loop-vref-pvt/,
* copied verbatim and wired exactly as design/bandgap_top.sch specifies,
* EXCEPT the single shared "fb" node is split into TWO nodes for this
* testbench only:
*   fb_src  -- bandgap_amp's own output (MP4/MN3 drains -- what design/
*              bandgap_amp.sch's header calls "out")
*   fb_load -- everything fb_src normally drives directly: bandgap_core's
*              three PMOS mirror gates (M1/M2/M3) and bandgap_startup's
*              XMKFB drain (via the same Vmkfb 0V ammeter fixture
*              sim/closed-loop-startup/ uses)
* A large inductor (Lbreak, 1e9 H) connects fb_src to fb_load: at DC an
* ideal inductor is a short circuit REGARDLESS of its inductance, so this
* preserves the closed-loop DC operating point exactly (fb_src=fb_load, the
* same constraint the real single "fb" node enforces) while presenting a
* huge (>1e17 ohm at the lowest swept frequency) AC impedance, breaking the
* loop for the .ac analysis without touching its DC bias. A small-signal AC
* voltage source (Vtest, 1V/0deg, DC=0V) is injected in series with Lbreak
* between fb_src and fb_load -- Middlebrook's classic single voltage-
* injection loop-gain probe. This break point is deliberately chosen
* because fb_load's OTHER connections are all MOS gates (M1/M2/M3's gates,
* XMKFB's drain via a 0V ammeter) -- i.e. a high-impedance load looking
* into the forward path from the injection point, and fb_src is a real,
* comparatively low-impedance amplifier output -- exactly the impedance
* asymmetry single voltage injection needs to be accurate (see README).
*
* Loop gain (this testbench's own sign convention, see README "Sign
* convention"): T(s) = V(fb_src)/V(fb_load). Phase margin = phase(T(jwc))
* at the frequency wc where |T(jwc)| = 1 (0 dB), given phase(T) starts near
* +180 deg at DC (the negative-feedback loop's own sign, already baked into
* this ratio -- verified empirically, not assumed, see README).
*
* ------------------------------------------------------- DC bias: nodeset
* This circuit has (at least) two DC equilibria -- the intended closed-loop
* operating point AND the degenerate all-off state design/bandgap_startup.sch
* exists to kick it out of (see that schematic's own header and
* sim/closed-loop-startup/README.md's account of why a plain vdd ramp is
* even needed there). A bare `.op` on the loop-BROKEN topology below, with
* no transient bring-up and no bias hint, has no guaranteed way to land in
* the intended basin -- and this testbench genuinely cannot reuse
* sim/closed-loop-startup's own vdd-ramp bring-up transient directly: doing
* so with the loop already split at fb_src/fb_load starves fb_load's DC/
* transient dynamics (its only other connections are MOS gates and one
* ammeter -- effectively no fast current path except through Lbreak, whose
* L/R time constant is enormous relative to the ramp), corrupting the
* bring-up itself (confirmed empirically during this issue's own dev-time
* prototyping -- every L tried, from 1H to 1e9H, either failed to converge
* the transient or settled somewhere far from
* sim/closed-loop-startup's own known-correct endpoint).
*
* The fix used here: seed a `.nodeset` (an initial-guess HINT for `.op`'s
* Newton-Raphson iteration, not an enforced constraint -- unlike `.ic`) at
* fb_load/fb_src/sns1/sns2/vref using the EXACT converged values
* sim/closed-loop-startup's own vdd-ramp transient already found for this
* same corner/temp/vdd point (read from its most recent committed record by
* run_pvt_sweep.sh at generation time -- see that script and the README's
* "Nodeset provenance" section). Since the seed IS (very nearly) the real
* answer, `.op`'s Newton-Raphson converges back to it directly rather than
* searching -- confirmed empirically across 6 spot-checked corners during
* dev-time prototyping to reproduce sim/closed-loop-startup's own fb/sns1/
* sns2/vref values to 3-4 significant figures despite only 5 of this
* circuit's ~13 non-trivial nodes being seeded. run_pvt_sweep.sh itself
* re-verifies this for every one of the 45 points in this sweep (not just
* the dev-time spot check) via the "op landed near its seed" sanity check
* documented in the README -- a point whose `.op` result strays far from
* its own seed fails outright rather than silently reporting a bogus
* loop-gain number from the wrong equilibrium.
.nodeset v(fb_load)=2.41862e+00 v(fb_src)=2.41862e+00 v(sns1)=7.88805e-01 v(sns2)=7.88535e-01 v(vref)=1.04938e+00

* DUT REFRESH (issue #264) -- the core DUT below is the TRIM-BEARING
* bandgap_core: R1 is segmented to its base l=37.2u into node tn0, and
* XXTRIM (the 255-unit binary-weighted rppd trim ladder landed by issue
* #229 -- see design/bandgap_trim_network.md) continues tn0 -> cb3. The
* ladder subcircuit below is copied device-for-device from
* design/netlist/bandgap_trim.spice, with its subcircuit-local
* .param trim_code pinned to the schematic default 128. This bench has NO
* trim-code axis (the code-swept benches are sim/trim-coverage/,
* sim/closed-loop-vref-trim-mc/ and sim/closed-loop-vref-boxtc-trim/);
* code 128 reproduces the pre-trim 511 um summing resistor to within ~3
* ohm, so this record's claim is the same claim the superseded pre-trim
* record made, re-measured against today's device set.

.lib "${PDK_ROOT}/ihp-sg13g2/libs.tech/ngspice/models/cornerHBT.lib" hbt_wcs
.lib "${PDK_ROOT}/ihp-sg13g2/libs.tech/ngspice/models/cornerMOShv.lib" mos_ss
.lib "${PDK_ROOT}/ihp-sg13g2/libs.tech/ngspice/models/cornerRES.lib" res_wcs

* temperature: klt sim's own per-corner `.temp` card (issue #271)
.options tnom=27

* FIXTURE -- vdd is a FIXED DC source here (not the transient ramp
* sim/closed-loop-startup/sim/closed-loop-vref-pvt use): this testbench
* measures a small-signal AC property of one already-settled DC operating
* point (seeded via .nodeset above), not a startup transient.
Vvdd vdd 0 dc 3.30
Vvss vss 0 dc 0
Vsub sub! vss dc 0

* DUT -- design/netlist/bandgap_core.spice, verbatim, EXCEPT gates tied to
* fb_load instead of fb (see "loop-break method" above). M2/M3 decomposed
* into per-leg-distinct counts (1/2/3) of dominant-plus-trim-finger
* sg13_hv_pmos instances (issue #149, T1 tracker #4 item 4 cause (d) --
* breaks the M1/M2/M3 LVS graph automorphism at the schematic level; each
* branch's total mirror W/L stays 10u/1u nominally -- see
* sim/closed-loop-vref-pvt/testbench/tb_closed_loop_vref.spice.tmpl's own
* header for the fuller rationale and the {1,2,3} split's not-quite-exact
* electrical caveat, not repeated here).
XM1 sns1 fb_load vdd vdd sg13_hv_pmos w=10u l=1u ng=1 m=1
XQ1 sns1 sns1 vss vss npn13G2 Nx=1
XM2A sns2 fb_load vdd vdd sg13_hv_pmos w=9u l=1u ng=1 m=1
XM2B sns2 fb_load vdd vdd sg13_hv_pmos w=1u l=1u ng=1 m=1
XR2 sns2 cb2 sub! rppd w=2u l=82.7u m=1 b=0
XQ2 cb2 cb2 vss vss npn13G2 Nx=8
XM3A vref fb_load vdd vdd sg13_hv_pmos w=8u l=1u ng=1 m=1
XM3B vref fb_load vdd vdd sg13_hv_pmos w=1u l=1u ng=1 m=1
XM3C vref fb_load vdd vdd sg13_hv_pmos w=1u l=1u ng=1 m=1
XR1 vref tn0 sub! rppd w=2u l=37.2u m=1 b=0
XXTRIM tn0 cb3 sub! bandgap_trim
XQ3 cb3 cb3 vss vss npn13G2 Nx=1

.subckt bandgap_trim in out sub
*.iopin in
*.iopin out
*.iopin sub
XRU1 in t001 sub rppd w=2u l=3.43u m=1 b=0
XRU2 t001 t002 sub rppd w=2u l=3.43u m=1 b=0
XRU3 t002 t003 sub rppd w=2u l=3.43u m=1 b=0
XRU4 t003 t004 sub rppd w=2u l=3.43u m=1 b=0
XRU5 t004 t005 sub rppd w=2u l=3.43u m=1 b=0
XRU6 t005 t006 sub rppd w=2u l=3.43u m=1 b=0
XRU7 t006 t007 sub rppd w=2u l=3.43u m=1 b=0
XRU8 t007 t008 sub rppd w=2u l=3.43u m=1 b=0
XRU9 t008 t009 sub rppd w=2u l=3.43u m=1 b=0
XRU10 t009 t010 sub rppd w=2u l=3.43u m=1 b=0
XRU11 t010 t011 sub rppd w=2u l=3.43u m=1 b=0
XRU12 t011 t012 sub rppd w=2u l=3.43u m=1 b=0
XRU13 t012 t013 sub rppd w=2u l=3.43u m=1 b=0
XRU14 t013 t014 sub rppd w=2u l=3.43u m=1 b=0
XRU15 t014 t015 sub rppd w=2u l=3.43u m=1 b=0
XRU16 t015 t016 sub rppd w=2u l=3.43u m=1 b=0
XRU17 t016 t017 sub rppd w=2u l=3.43u m=1 b=0
XRU18 t017 t018 sub rppd w=2u l=3.43u m=1 b=0
XRU19 t018 t019 sub rppd w=2u l=3.43u m=1 b=0
XRU20 t019 t020 sub rppd w=2u l=3.43u m=1 b=0
XRU21 t020 t021 sub rppd w=2u l=3.43u m=1 b=0
XRU22 t021 t022 sub rppd w=2u l=3.43u m=1 b=0
XRU23 t022 t023 sub rppd w=2u l=3.43u m=1 b=0
XRU24 t023 t024 sub rppd w=2u l=3.43u m=1 b=0
XRU25 t024 t025 sub rppd w=2u l=3.43u m=1 b=0
XRU26 t025 t026 sub rppd w=2u l=3.43u m=1 b=0
XRU27 t026 t027 sub rppd w=2u l=3.43u m=1 b=0
XRU28 t027 t028 sub rppd w=2u l=3.43u m=1 b=0
XRU29 t028 t029 sub rppd w=2u l=3.43u m=1 b=0
XRU30 t029 t030 sub rppd w=2u l=3.43u m=1 b=0
XRU31 t030 t031 sub rppd w=2u l=3.43u m=1 b=0
XRU32 t031 t032 sub rppd w=2u l=3.43u m=1 b=0
XRU33 t032 t033 sub rppd w=2u l=3.43u m=1 b=0
XRU34 t033 t034 sub rppd w=2u l=3.43u m=1 b=0
XRU35 t034 t035 sub rppd w=2u l=3.43u m=1 b=0
XRU36 t035 t036 sub rppd w=2u l=3.43u m=1 b=0
XRU37 t036 t037 sub rppd w=2u l=3.43u m=1 b=0
XRU38 t037 t038 sub rppd w=2u l=3.43u m=1 b=0
XRU39 t038 t039 sub rppd w=2u l=3.43u m=1 b=0
XRU40 t039 t040 sub rppd w=2u l=3.43u m=1 b=0
XRU41 t040 t041 sub rppd w=2u l=3.43u m=1 b=0
XRU42 t041 t042 sub rppd w=2u l=3.43u m=1 b=0
XRU43 t042 t043 sub rppd w=2u l=3.43u m=1 b=0
XRU44 t043 t044 sub rppd w=2u l=3.43u m=1 b=0
XRU45 t044 t045 sub rppd w=2u l=3.43u m=1 b=0
XRU46 t045 t046 sub rppd w=2u l=3.43u m=1 b=0
XRU47 t046 t047 sub rppd w=2u l=3.43u m=1 b=0
XRU48 t047 t048 sub rppd w=2u l=3.43u m=1 b=0
XRU49 t048 t049 sub rppd w=2u l=3.43u m=1 b=0
XRU50 t049 t050 sub rppd w=2u l=3.43u m=1 b=0
XRU51 t050 t051 sub rppd w=2u l=3.43u m=1 b=0
XRU52 t051 t052 sub rppd w=2u l=3.43u m=1 b=0
XRU53 t052 t053 sub rppd w=2u l=3.43u m=1 b=0
XRU54 t053 t054 sub rppd w=2u l=3.43u m=1 b=0
XRU55 t054 t055 sub rppd w=2u l=3.43u m=1 b=0
XRU56 t055 t056 sub rppd w=2u l=3.43u m=1 b=0
XRU57 t056 t057 sub rppd w=2u l=3.43u m=1 b=0
XRU58 t057 t058 sub rppd w=2u l=3.43u m=1 b=0
XRU59 t058 t059 sub rppd w=2u l=3.43u m=1 b=0
XRU60 t059 t060 sub rppd w=2u l=3.43u m=1 b=0
XRU61 t060 t061 sub rppd w=2u l=3.43u m=1 b=0
XRU62 t061 t062 sub rppd w=2u l=3.43u m=1 b=0
XRU63 t062 t063 sub rppd w=2u l=3.43u m=1 b=0
XRU64 t063 t064 sub rppd w=2u l=3.43u m=1 b=0
XRU65 t064 t065 sub rppd w=2u l=3.43u m=1 b=0
XRU66 t065 t066 sub rppd w=2u l=3.43u m=1 b=0
XRU67 t066 t067 sub rppd w=2u l=3.43u m=1 b=0
XRU68 t067 t068 sub rppd w=2u l=3.43u m=1 b=0
XRU69 t068 t069 sub rppd w=2u l=3.43u m=1 b=0
XRU70 t069 t070 sub rppd w=2u l=3.43u m=1 b=0
XRU71 t070 t071 sub rppd w=2u l=3.43u m=1 b=0
XRU72 t071 t072 sub rppd w=2u l=3.43u m=1 b=0
XRU73 t072 t073 sub rppd w=2u l=3.43u m=1 b=0
XRU74 t073 t074 sub rppd w=2u l=3.43u m=1 b=0
XRU75 t074 t075 sub rppd w=2u l=3.43u m=1 b=0
XRU76 t075 t076 sub rppd w=2u l=3.43u m=1 b=0
XRU77 t076 t077 sub rppd w=2u l=3.43u m=1 b=0
XRU78 t077 t078 sub rppd w=2u l=3.43u m=1 b=0
XRU79 t078 t079 sub rppd w=2u l=3.43u m=1 b=0
XRU80 t079 t080 sub rppd w=2u l=3.43u m=1 b=0
XRU81 t080 t081 sub rppd w=2u l=3.43u m=1 b=0
XRU82 t081 t082 sub rppd w=2u l=3.43u m=1 b=0
XRU83 t082 t083 sub rppd w=2u l=3.43u m=1 b=0
XRU84 t083 t084 sub rppd w=2u l=3.43u m=1 b=0
XRU85 t084 t085 sub rppd w=2u l=3.43u m=1 b=0
XRU86 t085 t086 sub rppd w=2u l=3.43u m=1 b=0
XRU87 t086 t087 sub rppd w=2u l=3.43u m=1 b=0
XRU88 t087 t088 sub rppd w=2u l=3.43u m=1 b=0
XRU89 t088 t089 sub rppd w=2u l=3.43u m=1 b=0
XRU90 t089 t090 sub rppd w=2u l=3.43u m=1 b=0
XRU91 t090 t091 sub rppd w=2u l=3.43u m=1 b=0
XRU92 t091 t092 sub rppd w=2u l=3.43u m=1 b=0
XRU93 t092 t093 sub rppd w=2u l=3.43u m=1 b=0
XRU94 t093 t094 sub rppd w=2u l=3.43u m=1 b=0
XRU95 t094 t095 sub rppd w=2u l=3.43u m=1 b=0
XRU96 t095 t096 sub rppd w=2u l=3.43u m=1 b=0
XRU97 t096 t097 sub rppd w=2u l=3.43u m=1 b=0
XRU98 t097 t098 sub rppd w=2u l=3.43u m=1 b=0
XRU99 t098 t099 sub rppd w=2u l=3.43u m=1 b=0
XRU100 t099 t100 sub rppd w=2u l=3.43u m=1 b=0
XRU101 t100 t101 sub rppd w=2u l=3.43u m=1 b=0
XRU102 t101 t102 sub rppd w=2u l=3.43u m=1 b=0
XRU103 t102 t103 sub rppd w=2u l=3.43u m=1 b=0
XRU104 t103 t104 sub rppd w=2u l=3.43u m=1 b=0
XRU105 t104 t105 sub rppd w=2u l=3.43u m=1 b=0
XRU106 t105 t106 sub rppd w=2u l=3.43u m=1 b=0
XRU107 t106 t107 sub rppd w=2u l=3.43u m=1 b=0
XRU108 t107 t108 sub rppd w=2u l=3.43u m=1 b=0
XRU109 t108 t109 sub rppd w=2u l=3.43u m=1 b=0
XRU110 t109 t110 sub rppd w=2u l=3.43u m=1 b=0
XRU111 t110 t111 sub rppd w=2u l=3.43u m=1 b=0
XRU112 t111 t112 sub rppd w=2u l=3.43u m=1 b=0
XRU113 t112 t113 sub rppd w=2u l=3.43u m=1 b=0
XRU114 t113 t114 sub rppd w=2u l=3.43u m=1 b=0
XRU115 t114 t115 sub rppd w=2u l=3.43u m=1 b=0
XRU116 t115 t116 sub rppd w=2u l=3.43u m=1 b=0
XRU117 t116 t117 sub rppd w=2u l=3.43u m=1 b=0
XRU118 t117 t118 sub rppd w=2u l=3.43u m=1 b=0
XRU119 t118 t119 sub rppd w=2u l=3.43u m=1 b=0
XRU120 t119 t120 sub rppd w=2u l=3.43u m=1 b=0
XRU121 t120 t121 sub rppd w=2u l=3.43u m=1 b=0
XRU122 t121 t122 sub rppd w=2u l=3.43u m=1 b=0
XRU123 t122 t123 sub rppd w=2u l=3.43u m=1 b=0
XRU124 t123 t124 sub rppd w=2u l=3.43u m=1 b=0
XRU125 t124 t125 sub rppd w=2u l=3.43u m=1 b=0
XRU126 t125 t126 sub rppd w=2u l=3.43u m=1 b=0
XRU127 t126 t127 sub rppd w=2u l=3.43u m=1 b=0
XRU128 t127 t128 sub rppd w=2u l=3.43u m=1 b=0
XRU129 t128 t129 sub rppd w=2u l=3.43u m=1 b=0
XRU130 t129 t130 sub rppd w=2u l=3.43u m=1 b=0
XRU131 t130 t131 sub rppd w=2u l=3.43u m=1 b=0
XRU132 t131 t132 sub rppd w=2u l=3.43u m=1 b=0
XRU133 t132 t133 sub rppd w=2u l=3.43u m=1 b=0
XRU134 t133 t134 sub rppd w=2u l=3.43u m=1 b=0
XRU135 t134 t135 sub rppd w=2u l=3.43u m=1 b=0
XRU136 t135 t136 sub rppd w=2u l=3.43u m=1 b=0
XRU137 t136 t137 sub rppd w=2u l=3.43u m=1 b=0
XRU138 t137 t138 sub rppd w=2u l=3.43u m=1 b=0
XRU139 t138 t139 sub rppd w=2u l=3.43u m=1 b=0
XRU140 t139 t140 sub rppd w=2u l=3.43u m=1 b=0
XRU141 t140 t141 sub rppd w=2u l=3.43u m=1 b=0
XRU142 t141 t142 sub rppd w=2u l=3.43u m=1 b=0
XRU143 t142 t143 sub rppd w=2u l=3.43u m=1 b=0
XRU144 t143 t144 sub rppd w=2u l=3.43u m=1 b=0
XRU145 t144 t145 sub rppd w=2u l=3.43u m=1 b=0
XRU146 t145 t146 sub rppd w=2u l=3.43u m=1 b=0
XRU147 t146 t147 sub rppd w=2u l=3.43u m=1 b=0
XRU148 t147 t148 sub rppd w=2u l=3.43u m=1 b=0
XRU149 t148 t149 sub rppd w=2u l=3.43u m=1 b=0
XRU150 t149 t150 sub rppd w=2u l=3.43u m=1 b=0
XRU151 t150 t151 sub rppd w=2u l=3.43u m=1 b=0
XRU152 t151 t152 sub rppd w=2u l=3.43u m=1 b=0
XRU153 t152 t153 sub rppd w=2u l=3.43u m=1 b=0
XRU154 t153 t154 sub rppd w=2u l=3.43u m=1 b=0
XRU155 t154 t155 sub rppd w=2u l=3.43u m=1 b=0
XRU156 t155 t156 sub rppd w=2u l=3.43u m=1 b=0
XRU157 t156 t157 sub rppd w=2u l=3.43u m=1 b=0
XRU158 t157 t158 sub rppd w=2u l=3.43u m=1 b=0
XRU159 t158 t159 sub rppd w=2u l=3.43u m=1 b=0
XRU160 t159 t160 sub rppd w=2u l=3.43u m=1 b=0
XRU161 t160 t161 sub rppd w=2u l=3.43u m=1 b=0
XRU162 t161 t162 sub rppd w=2u l=3.43u m=1 b=0
XRU163 t162 t163 sub rppd w=2u l=3.43u m=1 b=0
XRU164 t163 t164 sub rppd w=2u l=3.43u m=1 b=0
XRU165 t164 t165 sub rppd w=2u l=3.43u m=1 b=0
XRU166 t165 t166 sub rppd w=2u l=3.43u m=1 b=0
XRU167 t166 t167 sub rppd w=2u l=3.43u m=1 b=0
XRU168 t167 t168 sub rppd w=2u l=3.43u m=1 b=0
XRU169 t168 t169 sub rppd w=2u l=3.43u m=1 b=0
XRU170 t169 t170 sub rppd w=2u l=3.43u m=1 b=0
XRU171 t170 t171 sub rppd w=2u l=3.43u m=1 b=0
XRU172 t171 t172 sub rppd w=2u l=3.43u m=1 b=0
XRU173 t172 t173 sub rppd w=2u l=3.43u m=1 b=0
XRU174 t173 t174 sub rppd w=2u l=3.43u m=1 b=0
XRU175 t174 t175 sub rppd w=2u l=3.43u m=1 b=0
XRU176 t175 t176 sub rppd w=2u l=3.43u m=1 b=0
XRU177 t176 t177 sub rppd w=2u l=3.43u m=1 b=0
XRU178 t177 t178 sub rppd w=2u l=3.43u m=1 b=0
XRU179 t178 t179 sub rppd w=2u l=3.43u m=1 b=0
XRU180 t179 t180 sub rppd w=2u l=3.43u m=1 b=0
XRU181 t180 t181 sub rppd w=2u l=3.43u m=1 b=0
XRU182 t181 t182 sub rppd w=2u l=3.43u m=1 b=0
XRU183 t182 t183 sub rppd w=2u l=3.43u m=1 b=0
XRU184 t183 t184 sub rppd w=2u l=3.43u m=1 b=0
XRU185 t184 t185 sub rppd w=2u l=3.43u m=1 b=0
XRU186 t185 t186 sub rppd w=2u l=3.43u m=1 b=0
XRU187 t186 t187 sub rppd w=2u l=3.43u m=1 b=0
XRU188 t187 t188 sub rppd w=2u l=3.43u m=1 b=0
XRU189 t188 t189 sub rppd w=2u l=3.43u m=1 b=0
XRU190 t189 t190 sub rppd w=2u l=3.43u m=1 b=0
XRU191 t190 t191 sub rppd w=2u l=3.43u m=1 b=0
XRU192 t191 t192 sub rppd w=2u l=3.43u m=1 b=0
XRU193 t192 t193 sub rppd w=2u l=3.43u m=1 b=0
XRU194 t193 t194 sub rppd w=2u l=3.43u m=1 b=0
XRU195 t194 t195 sub rppd w=2u l=3.43u m=1 b=0
XRU196 t195 t196 sub rppd w=2u l=3.43u m=1 b=0
XRU197 t196 t197 sub rppd w=2u l=3.43u m=1 b=0
XRU198 t197 t198 sub rppd w=2u l=3.43u m=1 b=0
XRU199 t198 t199 sub rppd w=2u l=3.43u m=1 b=0
XRU200 t199 t200 sub rppd w=2u l=3.43u m=1 b=0
XRU201 t200 t201 sub rppd w=2u l=3.43u m=1 b=0
XRU202 t201 t202 sub rppd w=2u l=3.43u m=1 b=0
XRU203 t202 t203 sub rppd w=2u l=3.43u m=1 b=0
XRU204 t203 t204 sub rppd w=2u l=3.43u m=1 b=0
XRU205 t204 t205 sub rppd w=2u l=3.43u m=1 b=0
XRU206 t205 t206 sub rppd w=2u l=3.43u m=1 b=0
XRU207 t206 t207 sub rppd w=2u l=3.43u m=1 b=0
XRU208 t207 t208 sub rppd w=2u l=3.43u m=1 b=0
XRU209 t208 t209 sub rppd w=2u l=3.43u m=1 b=0
XRU210 t209 t210 sub rppd w=2u l=3.43u m=1 b=0
XRU211 t210 t211 sub rppd w=2u l=3.43u m=1 b=0
XRU212 t211 t212 sub rppd w=2u l=3.43u m=1 b=0
XRU213 t212 t213 sub rppd w=2u l=3.43u m=1 b=0
XRU214 t213 t214 sub rppd w=2u l=3.43u m=1 b=0
XRU215 t214 t215 sub rppd w=2u l=3.43u m=1 b=0
XRU216 t215 t216 sub rppd w=2u l=3.43u m=1 b=0
XRU217 t216 t217 sub rppd w=2u l=3.43u m=1 b=0
XRU218 t217 t218 sub rppd w=2u l=3.43u m=1 b=0
XRU219 t218 t219 sub rppd w=2u l=3.43u m=1 b=0
XRU220 t219 t220 sub rppd w=2u l=3.43u m=1 b=0
XRU221 t220 t221 sub rppd w=2u l=3.43u m=1 b=0
XRU222 t221 t222 sub rppd w=2u l=3.43u m=1 b=0
XRU223 t222 t223 sub rppd w=2u l=3.43u m=1 b=0
XRU224 t223 t224 sub rppd w=2u l=3.43u m=1 b=0
XRU225 t224 t225 sub rppd w=2u l=3.43u m=1 b=0
XRU226 t225 t226 sub rppd w=2u l=3.43u m=1 b=0
XRU227 t226 t227 sub rppd w=2u l=3.43u m=1 b=0
XRU228 t227 t228 sub rppd w=2u l=3.43u m=1 b=0
XRU229 t228 t229 sub rppd w=2u l=3.43u m=1 b=0
XRU230 t229 t230 sub rppd w=2u l=3.43u m=1 b=0
XRU231 t230 t231 sub rppd w=2u l=3.43u m=1 b=0
XRU232 t231 t232 sub rppd w=2u l=3.43u m=1 b=0
XRU233 t232 t233 sub rppd w=2u l=3.43u m=1 b=0
XRU234 t233 t234 sub rppd w=2u l=3.43u m=1 b=0
XRU235 t234 t235 sub rppd w=2u l=3.43u m=1 b=0
XRU236 t235 t236 sub rppd w=2u l=3.43u m=1 b=0
XRU237 t236 t237 sub rppd w=2u l=3.43u m=1 b=0
XRU238 t237 t238 sub rppd w=2u l=3.43u m=1 b=0
XRU239 t238 t239 sub rppd w=2u l=3.43u m=1 b=0
XRU240 t239 t240 sub rppd w=2u l=3.43u m=1 b=0
XRU241 t240 t241 sub rppd w=2u l=3.43u m=1 b=0
XRU242 t241 t242 sub rppd w=2u l=3.43u m=1 b=0
XRU243 t242 t243 sub rppd w=2u l=3.43u m=1 b=0
XRU244 t243 t244 sub rppd w=2u l=3.43u m=1 b=0
XRU245 t244 t245 sub rppd w=2u l=3.43u m=1 b=0
XRU246 t245 t246 sub rppd w=2u l=3.43u m=1 b=0
XRU247 t246 t247 sub rppd w=2u l=3.43u m=1 b=0
XRU248 t247 t248 sub rppd w=2u l=3.43u m=1 b=0
XRU249 t248 t249 sub rppd w=2u l=3.43u m=1 b=0
XRU250 t249 t250 sub rppd w=2u l=3.43u m=1 b=0
XRU251 t250 t251 sub rppd w=2u l=3.43u m=1 b=0
XRU252 t251 t252 sub rppd w=2u l=3.43u m=1 b=0
XRU253 t252 t253 sub rppd w=2u l=3.43u m=1 b=0
XRU254 t253 t254 sub rppd w=2u l=3.43u m=1 b=0
XRU255 t254 out sub rppd w=2u l=3.43u m=1 b=0
RS0 in t001 {1e-3 + 1e12*(floor(trim_code/1)-2*floor(trim_code/2))} m=1
RS1 t001 t003 {1e-3 + 1e12*(floor(trim_code/2)-2*floor(trim_code/4))} m=1
RS2 t003 t007 {1e-3 + 1e12*(floor(trim_code/4)-2*floor(trim_code/8))} m=1
RS3 t007 t015 {1e-3 + 1e12*(floor(trim_code/8)-2*floor(trim_code/16))} m=1
RS4 t015 t031 {1e-3 + 1e12*(floor(trim_code/16)-2*floor(trim_code/32))} m=1
RS5 t031 t063 {1e-3 + 1e12*(floor(trim_code/32)-2*floor(trim_code/64))} m=1
RS6 t063 t127 {1e-3 + 1e12*(floor(trim_code/64)-2*floor(trim_code/128))} m=1
RS7 t127 out {1e-3 + 1e12*(floor(trim_code/128)-2*floor(trim_code/256))} m=1
**** begin user architecture code
.param trim_code=128
**** end user architecture code
.ends

* DUT -- design/netlist/bandgap_amp.spice, verbatim, EXCEPT the output
* devices (MP4 drain, MN3 drain) are tied to fb_src instead of fb/out (see
* "loop-break method" above). in_p <- sns2 (non-inverting), in_n <- sns1
* (inverting) -- unchanged from design/bandgap_amp.sch's own polarity.
XMTAIL tail fb_src vdd vdd sg13_hv_pmos w=10u l=1u ng=1 m=1
XMP1 d1 sns2 tail vdd sg13_hv_pmos w=20u l=1u ng=1 m=1
XMP2 d2 sns1 tail vdd sg13_hv_pmos w=20u l=1u ng=1 m=1
XMP3 pn pn vdd vdd sg13_hv_pmos w=10u l=1u ng=1 m=1
XMP4 fb_src pn vdd vdd sg13_hv_pmos w=10u l=1u ng=1 m=1
XMN1 d1 d1 vss vss sg13_hv_nmos w=10u l=1u ng=1 m=1
XMN2 d2 d2 vss vss sg13_hv_nmos w=10u l=1u ng=1 m=1
XMN3 fb_src d1 vss vss sg13_hv_nmos w=10u l=1u ng=1 m=1
XMN4 pn d2 vss vss sg13_hv_nmos w=10u l=1u ng=1 m=1

* DUT -- design/netlist/bandgap_startup.spice, verbatim, EXCEPT XMKFB's
* drain is tied to fb_load instead of fb (via the same 0V Vmkfb ammeter
* fixture sim/closed-loop-startup/ uses). At the settled bias this .nodeset
* seeds, XMKFB is fully released (same as every PASS point in
* sim/closed-loop-startup) and contributes ~0 current either way.
XRPU vdd det sub! rhigh w=1u l=1411.3u m=1 b=0
XMSENSE det sns1 vss vss sg13_hv_nmos w=10u l=0.5u ng=1 m=1
Vmkfb fb_load fbx dc 0
XMKFB fbx det vss vss sg13_hv_nmos w=2u l=0.5u ng=1 m=1

* LOOP BREAK -- see "loop-break method" above. Lbreak's DC impedance is
* always 0 (ideal inductor), so it does not perturb the .nodeset-seeded DC
* operating point at all; only its AC (jwL) reactance matters, and that is
* confirmed >> this circuit's own node impedances at every frequency this
* testbench sweeps (empirically verified L-invariant between 1e6 H and
* 1e9 H during dev-time prototyping -- see README).
Lbreak fb_src brk 1e9
Vtest brk fb_load dc 0 ac 1 0

* ------------------------------------------- OP PROBE FIXTURE (issue #271)
* The bench's "op landed near its seed" check reads the DC operating point
* with `op` + `print`. Through `klt sim` that is not expressible: one
* analysis per request (AC here), measurements are `.meas` cards only (the
* batch runner's klt 0.5.0 predates `measurements[].expr`), and `.MEASURE`
* has no `op` type. So the DC bias is carried through the AC run instead:
* `acs` is an isolated node driven by its own 1 V AC / 0 V DC source, and each
* B-source below outputs V(node)*V(acs). Linearized about the operating
* point, its AC response is V(node)_dc * 1 + V(acs)_dc * v_ac(node) =
* V(node)_dc exactly (V(acs)_dc = 0), flat in frequency, real-valued. The
* B-sources only SENSE their controlling node (infinite input impedance) and
* drive nothing but their own 1 MOhm load, so the DUT is not perturbed; and
* `acs` reaches nothing but these B-sources, so Vacs adds no excitation to
* the loop Vtest measures.
Vacs acs 0 dc 0 ac 1
Bop_fb op_fb 0 V = V(fb_load)*V(acs)
Rop_fb op_fb 0 1e6
Bop_sns1 op_sns1 0 V = V(sns1)*V(acs)
Rop_sns1 op_sns1 0 1e6
Bop_sns2 op_sns2 0 V = V(sns2)*V(acs)
Rop_sns2 op_sns2 0 1e6
Bop_vref op_vref 0 V = V(vref)*V(acs)
Rop_vref op_vref 0 1e6

* Rawfile contents: the two loop-break nodes (T = V(fb_src)/V(fb_load)) and
* the four op probes. Nothing else is read, and a full `save all` rawfile at
* the fine grid would be ~100x larger.
.save v(fb_src) v(fb_load) v(op_fb) v(op_sns1) v(op_sns2) v(op_vref)

* OSDI preload only -- klt sim appends its own .control (alter + analysis).
.control
pre_osdi ${PDK_ROOT}/ihp-sg13g2/libs.tech/ngspice/osdi/psp103.osdi
pre_osdi ${PDK_ROOT}/ihp-sg13g2/libs.tech/ngspice/osdi/psp103_nqs.osdi
pre_osdi ${PDK_ROOT}/ihp-sg13g2/libs.tech/ngspice/osdi/mosvar.osdi
pre_osdi ${PDK_ROOT}/ihp-sg13g2/libs.tech/ngspice/osdi/r3_cmc.osdi
.endc
* --- end body.spice ---
.temp -40.0
.meas ac fb_op_v find v(op_fb) at=1
.meas ac sns1_op_v find v(op_sns1) at=1
.meas ac sns2_op_v find v(op_sns2) at=1
.meas ac vref_op_v find v(op_vref) at=1
.meas ac fb_src_db_1hz find vdb(fb_src) at=1
.meas ac fb_load_db_1hz find vdb(fb_load) at=1
.control
alter r.xxtrim.rs0=1000000000000.0
alter r.xxtrim.rs1=1000000000000.0
alter r.xxtrim.rs2=1000000000000.0
alter r.xxtrim.rs3=1000000000000.0
alter r.xxtrim.rs4=1000000000000.0
alter r.xxtrim.rs5=1000000000000.0
alter r.xxtrim.rs6=1000000000000.0
alter r.xxtrim.rs7=1000000000000.0
set filetype=ascii
ac dec 30 1 1e9
write waveform.raw
quit
.endc
.end
