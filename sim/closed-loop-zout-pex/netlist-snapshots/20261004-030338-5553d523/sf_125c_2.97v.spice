* klt sim -- generated corner deck, do not edit
.lib "/opt/pdk/ihp-sg13g2/libs.tech/ngspice/models/cornerHBT.lib" hbt_typ
* --- inlined .include body-fixed-sf-2p97.spice (klt_sim_evidence.py) ---
* sg13g2-bandgap -- closed-loop AC output-impedance-at-vref PEX bench body for the `klt sim`
* harness (issue #278, the remaining half of #275). Instantiated by
* sim/closed-loop-zout-pex/run_klt_sim.sh, which substitutes /opt/pdk/ihp-sg13g2/libs.tech/ngspice/osdi,
* 2.97, the four @@*_SEED@@ nodeset values (sim/closed-loop-startup's
* newest committed record, 125 C row for this process corner and supply
* -- the worst-corner stiffness; the fs/125 point singular-matrixed from
* the 27 C row on the refreshed extraction -- while the op-match check
* uses the per-temperature reference via --seed-csv) and pex_body.inc. The
* DUT half is GENERATED by `sim/tools/gen_pex_netlist_body.py --cell top`.
*
* `klt sim` netlist-body convention: this file is a circuit BODY. No
* `.lib`, no `.temp`, no `.options temp=`, no analysis card, no `.end`.
*
* WHY NODESET-SEEDED, NOT RAMP-SETTLED. The transient benches in this
* issue settle by ramping vdd 0->VDD and measuring the tail; this bench
* tried the same shape first and it DOES NOT TRANSFER: ngspice re-solves
* the DC operating point for an `ac` analysis from the sources' DC values
* -- a PWL source's DC value is its t=0 point (0 V), so the AC
* linearisation lands on a collapsed supply, not the settled equilibrium
* (verified on ngspice 46 with a nonlinear toy circuit; a linear one
* cannot distinguish the two -- the trap that hid this initially). The
* seeds below are therefore the old bench's own mechanism, kept: they are
* convergence AIDS, not constraints -- the op they seed is checked in the
* enrichment pass against this body's own .nodeset values with the old
* bench's 50 mV tolerance.
*
* TWO DELIBERATE DEVIATIONS, both disclosed in sim/harness/README.md
* "Upstream friction":
*
* 1. The `.control` pre_osdi block (klayout-tools#2666) -- same as every
*    `klt sim` body in this repo.
* 2. The `.control` block also carries the seeded `op`, the op prints and
*    the AC sweep: the request schema declares ONE analysis and a bench
*    that must print its operating points needs them log-side
*    (`measurements[].expr`, the 0.6.0 answer, postdates the runner
*    image's klt 0.5.0). The request's declared analysis is the same
*    `ac dec 30 1 1e9`; `.nodeset` cards are parse-time, so klt's own
*    re-run of the analysis lands on the same seeded op, and the
*    top-level `.meas ac` cards attach to it. The body's `print psrr_db`
*    table lands in the per-corner log, which
*    sim/harness/enrich_ac_report.py parses for the curve-extremum
*    columns (worst-case PSRR and its frequency -- not expressible as a
*    0.5.0 `.meas` at all).
.control
pre_osdi /opt/pdk/ihp-sg13g2/libs.tech/ngspice/osdi/psp103.osdi
pre_osdi /opt/pdk/ihp-sg13g2/libs.tech/ngspice/osdi/psp103_nqs.osdi
pre_osdi /opt/pdk/ihp-sg13g2/libs.tech/ngspice/osdi/mosvar.osdi
pre_osdi /opt/pdk/ihp-sg13g2/libs.tech/ngspice/osdi/r3_cmc.osdi
op
print v(fb)
print v(sns1)
print v(sns2)
print v(vref)
print v(det)
print i(Vmkfb)
ac dec 30 1 1e9
let zout_db = db(v(vref))
print zout_db
.endc

* Node seeds: sim/closed-loop-startup's committed per-corner DC-bias
* values (125 C row for this process corner and supply -- the
* worst-corner stiffness; see the header), from the same record
* sim/lib/nodeset_seed.sh established as the hand-transcribed bench's
* seed provenance. Checked, not trusted: the enrichment pass verifies
* the landed op against that record's per-temperature reference with
* the old bench's 50 mV tolerance.
.nodeset v(fb)=2.25352e+00 v(sns1)=5.89887e-01 v(sns2)=5.89273e-01 v(vref)=1.04230e+00

* Solver options: reltol=5e-3 (settled trim-bearing setting); rshunt/gmin
* deliberately absent (issue #278 -- ~0.55 uA ladder leak, ~37 mV vref
* artifact).
.options reltol=5e-3

* Resident-vector save (issue #278 work item 3): every vector the op
* prints, the meas cards and the print table read; nothing else resident.
.save v(fb) v(sns1) v(sns2) v(vref) v(det) i(Vmkfb)

* FIXTURE -- supply: a plain DC source, carrying NO AC term here. This
* experiment perturbs a completely different port: Itest injects the
* 1 A / 0 deg AC test current directly at vref (DC = 0, so it does not
* perturb the seeded DC operating point), and Zout = db(v(vref)) for a
* 1 A stimulus -- the injection method this experiment's README
* documents. 2.97 is substituted per supply by the runner (the seed
* set is per-supply too, so the supply axis lives in per-supply body
* variants, not in the request's `alter` channel).
Vvdd vdd 0 DC 2.97
Vvss vss 0 dc 0

* STIMULUS -- the 1 A / 0 deg AC test current at vref.
Itest 0 vref DC 0 AC 1 0

* FIXTURE -- vsubs is tied to vss through a 0 V source, NOT through the
* 1 TOhm DC tie the extraction itself carries (which remains in parallel,
* harmlessly): at AC a 1 TOhm return leaves vsubs effectively floating,
* and every extracted ground capacitance stops being a cap to ground and
* instead couples net-to-net in series with the other nets' ground caps --
* which is not what the layout does. In this bench the far plate IS the
* substrate and the substrate is tied to vss. The measured size of that
* choice is quantified, not asserted, in this experiment's README ("The
* vsubs tie matters here").
Vsubs_tie vsubs vss dc 0

* DUT -- generated PEX body for bandgap_top (Vmkfb split included, for
* topology parity with every other closed-loop bench; its current is not
* probed here -- this bench's measurement is the AC curve at vref).
* --- inlined .include pex_body.inc (klt_sim_evidence.py) ---
* PEX netlist body for bandgap_top -- GENERATED by sim/tools/gen_pex_netlist_body.py --cell top
* from layout/bandgap_top/bandgap_top.pex.spice and design/netlist/bandgap_top.spice (three subckts, flattened). Do not edit; regenerate.
* 17 MOS legs, 3 standalone resistors, 255 ladder units (XRU<n>), 3 spliced bipolars, 1 Vmkfb drain split;
* 908 wire-parasitic cards kept, 255 unreferenced hub legs dropped.
* Merged nets renamed: fb|out -> fb, in_n|sns1 -> sns1, in_p|sns2 -> sns2, t001|t003|t007|t015|t031|t063|t127|tn0 -> tn0
* Ladder naming: 14 units touch a tap-shorted group; where one tap sits
* between two merged taps the two adjacent units are geometrically identical and
* their XRU<n> names are a deterministic permutation, electrically exact and
* D2-equivalent (see sim/tools/gen_pex_netlist_body.py, 'Permutation').
* No XXTRIM and no RS<bit> cards: the realised trim code is mask metal.

* Devices
XMN1 d1__t0 d1__t1 vss__t0 vss__t264 sg13_hv_nmos w=10u l=1u ng=1 m=1 as=4p ad=4p ps=20.8u pd=20.8u
XMN2 d2__t3 d2__t1 vss__t3 vss__t265 sg13_hv_nmos w=10u l=1u ng=1 m=1 as=4p ad=4p ps=20.8u pd=20.8u
XMN3 fb__t9 d1__t3 vss__t5 vss__t266 sg13_hv_nmos w=10u l=1u ng=1 m=1 as=4p ad=4p ps=20.8u pd=20.8u
XMN4 pn__t3 d2__t2 vss__t4 vss__t267 sg13_hv_nmos w=10u l=1u ng=1 m=1 as=4p ad=4p ps=20.8u pd=20.8u
XMSENSE det__t0 sns1__t0 vss__t1 vss__t268 sg13_hv_nmos w=10u l=0.5u ng=1 m=1 as=4p ad=4p ps=20.8u pd=20.8u
XMKFB i_mkfb_probe det__t2 vss__t2 vss__t269 sg13_hv_nmos w=2u l=0.5u ng=1 m=1 as=0.8p ad=0.8p ps=4.8u pd=4.8u
Vmkfb fb__t1 i_mkfb_probe dc 0
XMP1 tail__t0 sns2__t0 d1__t2 vdd__t0 sg13_hv_pmos w=20u l=1u ng=1 m=1 as=8p ad=8p ps=40.8u pd=40.8u
XMP2 tail__t2 sns1__t2 d2__t0 vdd__t20 sg13_hv_pmos w=20u l=1u ng=1 m=1 as=8p ad=8p ps=40.8u pd=40.8u
XMTAIL vdd__t1 fb__t0 tail__t1 vdd__t2 sg13_hv_pmos w=10u l=1u ng=1 m=1 as=4p ad=4p ps=20.8u pd=20.8u
XMP3 vdd__t18 pn__t1 pn__t2 vdd__t15 sg13_hv_pmos w=10u l=1u ng=1 m=1 as=4p ad=4p ps=20.8u pd=20.8u
XMP4 vdd__t17 pn__t0 fb__t8 vdd__t14 sg13_hv_pmos w=10u l=1u ng=1 m=1 as=4p ad=4p ps=20.8u pd=20.8u
XM1 vdd__t19 fb__t7 sns1__t1 vdd__t16 sg13_hv_pmos w=10u l=1u ng=1 m=1 as=4p ad=4p ps=20.8u pd=20.8u
XM2A vdd__t4 fb__t2 sns2__t1 vdd__t5 sg13_hv_pmos w=9u l=1u ng=1 m=1 as=3.6p ad=3.6p ps=18.8u pd=18.8u
XM2B vdd__t6 fb__t3 sns2__t2 vdd__t7 sg13_hv_pmos w=1u l=1u ng=1 m=1 as=0.4p ad=0.4p ps=2.8u pd=2.8u
XM3A vdd__t8 fb__t4 vref__t0 vdd__t9 sg13_hv_pmos w=8u l=1u ng=1 m=1 as=3.2p ad=3.2p ps=16.8u pd=16.8u
XM3B vdd__t13 fb__t6 vref__t3 vdd__t11 sg13_hv_pmos w=1u l=1u ng=1 m=1 as=0.4p ad=0.4p ps=2.8u pd=2.8u
XM3C vdd__t12 fb__t5 vref__t2 vdd__t10 sg13_hv_pmos w=1u l=1u ng=1 m=1 as=0.4p ad=0.4p ps=2.8u pd=2.8u
XR2 sns2__t3 cb2__t0 vss__t261 rppd w=2u l=82.7u m=1 b=0
XR1 vref__t1 tn0__t2 vss__t262 rppd w=2u l=37.2u m=1 b=0
XRPU vdd__t3 det__t1 vss__t263 rhigh w=1u l=1411.3u m=1 b=0
XRU1 tn0__t0 tn0__t1 vsubs rppd w=2u l=3.43u m=1 b=0
XRU2 tn0__t5 t002__t1 vsubs rppd w=2u l=3.43u m=1 b=0
XRU3 t002__t0 tn0__t13 vsubs rppd w=2u l=3.43u m=1 b=0
XRU4 tn0__t11 t004__t0 vsubs rppd w=2u l=3.43u m=1 b=0
XRU5 t004__t1 t005__t0 vsubs rppd w=2u l=3.43u m=1 b=0
XRU6 t005__t1 t006__t0 vsubs rppd w=2u l=3.43u m=1 b=0
XRU7 t006__t1 tn0__t9 vsubs rppd w=2u l=3.43u m=1 b=0
XRU8 tn0__t15 t008__t0 vsubs rppd w=2u l=3.43u m=1 b=0
XRU9 t008__t1 t009__t0 vsubs rppd w=2u l=3.43u m=1 b=0
XRU10 t009__t1 t010__t0 vsubs rppd w=2u l=3.43u m=1 b=0
XRU11 t010__t1 t011__t0 vsubs rppd w=2u l=3.43u m=1 b=0
XRU12 t011__t1 t012__t0 vsubs rppd w=2u l=3.43u m=1 b=0
XRU13 t012__t1 t013__t0 vsubs rppd w=2u l=3.43u m=1 b=0
XRU14 t013__t1 t014__t0 vsubs rppd w=2u l=3.43u m=1 b=0
XRU15 t014__t1 tn0__t3 vsubs rppd w=2u l=3.43u m=1 b=0
XRU16 tn0__t4 t016__t1 vsubs rppd w=2u l=3.43u m=1 b=0
XRU17 t016__t0 t017__t1 vsubs rppd w=2u l=3.43u m=1 b=0
XRU18 t017__t0 t018__t1 vsubs rppd w=2u l=3.43u m=1 b=0
XRU19 t018__t0 t019__t1 vsubs rppd w=2u l=3.43u m=1 b=0
XRU20 t019__t0 t020__t1 vsubs rppd w=2u l=3.43u m=1 b=0
XRU21 t020__t0 t021__t1 vsubs rppd w=2u l=3.43u m=1 b=0
XRU22 t021__t0 t022__t1 vsubs rppd w=2u l=3.43u m=1 b=0
XRU23 t022__t0 t023__t1 vsubs rppd w=2u l=3.43u m=1 b=0
XRU24 t023__t0 t024__t1 vsubs rppd w=2u l=3.43u m=1 b=0
XRU25 t024__t0 t025__t1 vsubs rppd w=2u l=3.43u m=1 b=0
XRU26 t025__t0 t026__t1 vsubs rppd w=2u l=3.43u m=1 b=0
XRU27 t026__t0 t027__t1 vsubs rppd w=2u l=3.43u m=1 b=0
XRU28 t027__t0 t028__t1 vsubs rppd w=2u l=3.43u m=1 b=0
XRU29 t028__t0 t029__t1 vsubs rppd w=2u l=3.43u m=1 b=0
XRU30 t029__t0 t030__t1 vsubs rppd w=2u l=3.43u m=1 b=0
XRU31 t030__t0 tn0__t7 vsubs rppd w=2u l=3.43u m=1 b=0
XRU32 tn0__t10 t032__t0 vsubs rppd w=2u l=3.43u m=1 b=0
XRU33 t032__t1 t033__t0 vsubs rppd w=2u l=3.43u m=1 b=0
XRU34 t033__t1 t034__t0 vsubs rppd w=2u l=3.43u m=1 b=0
XRU35 t034__t1 t035__t0 vsubs rppd w=2u l=3.43u m=1 b=0
XRU36 t035__t1 t036__t0 vsubs rppd w=2u l=3.43u m=1 b=0
XRU37 t036__t1 t037__t0 vsubs rppd w=2u l=3.43u m=1 b=0
XRU38 t037__t1 t038__t0 vsubs rppd w=2u l=3.43u m=1 b=0
XRU39 t038__t1 t039__t0 vsubs rppd w=2u l=3.43u m=1 b=0
XRU40 t039__t1 t040__t0 vsubs rppd w=2u l=3.43u m=1 b=0
XRU41 t040__t1 t041__t0 vsubs rppd w=2u l=3.43u m=1 b=0
XRU42 t041__t1 t042__t0 vsubs rppd w=2u l=3.43u m=1 b=0
XRU43 t042__t1 t043__t0 vsubs rppd w=2u l=3.43u m=1 b=0
XRU44 t043__t1 t044__t0 vsubs rppd w=2u l=3.43u m=1 b=0
XRU45 t044__t1 t045__t0 vsubs rppd w=2u l=3.43u m=1 b=0
XRU46 t045__t1 t046__t1 vsubs rppd w=2u l=3.43u m=1 b=0
XRU47 t046__t0 t047__t1 vsubs rppd w=2u l=3.43u m=1 b=0
XRU48 t047__t0 t048__t1 vsubs rppd w=2u l=3.43u m=1 b=0
XRU49 t048__t0 t049__t1 vsubs rppd w=2u l=3.43u m=1 b=0
XRU50 t049__t0 t050__t1 vsubs rppd w=2u l=3.43u m=1 b=0
XRU51 t050__t0 t051__t1 vsubs rppd w=2u l=3.43u m=1 b=0
XRU52 t051__t0 t052__t1 vsubs rppd w=2u l=3.43u m=1 b=0
XRU53 t052__t0 t053__t1 vsubs rppd w=2u l=3.43u m=1 b=0
XRU54 t053__t0 t054__t1 vsubs rppd w=2u l=3.43u m=1 b=0
XRU55 t054__t0 t055__t1 vsubs rppd w=2u l=3.43u m=1 b=0
XRU56 t055__t0 t056__t1 vsubs rppd w=2u l=3.43u m=1 b=0
XRU57 t056__t0 t057__t1 vsubs rppd w=2u l=3.43u m=1 b=0
XRU58 t057__t0 t058__t1 vsubs rppd w=2u l=3.43u m=1 b=0
XRU59 t058__t0 t059__t1 vsubs rppd w=2u l=3.43u m=1 b=0
XRU60 t059__t0 t060__t1 vsubs rppd w=2u l=3.43u m=1 b=0
XRU61 t060__t0 t061__t0 vsubs rppd w=2u l=3.43u m=1 b=0
XRU62 t061__t1 t062__t0 vsubs rppd w=2u l=3.43u m=1 b=0
XRU63 t062__t1 tn0__t6 vsubs rppd w=2u l=3.43u m=1 b=0
XRU64 tn0__t14 t064__t0 vsubs rppd w=2u l=3.43u m=1 b=0
XRU65 t064__t1 t065__t0 vsubs rppd w=2u l=3.43u m=1 b=0
XRU66 t065__t1 t066__t0 vsubs rppd w=2u l=3.43u m=1 b=0
XRU67 t066__t1 t067__t0 vsubs rppd w=2u l=3.43u m=1 b=0
XRU68 t067__t1 t068__t0 vsubs rppd w=2u l=3.43u m=1 b=0
XRU69 t068__t1 t069__t0 vsubs rppd w=2u l=3.43u m=1 b=0
XRU70 t069__t1 t070__t0 vsubs rppd w=2u l=3.43u m=1 b=0
XRU71 t070__t1 t071__t0 vsubs rppd w=2u l=3.43u m=1 b=0
XRU72 t071__t1 t072__t0 vsubs rppd w=2u l=3.43u m=1 b=0
XRU73 t072__t1 t073__t0 vsubs rppd w=2u l=3.43u m=1 b=0
XRU74 t073__t1 t074__t0 vsubs rppd w=2u l=3.43u m=1 b=0
XRU75 t074__t1 t075__t0 vsubs rppd w=2u l=3.43u m=1 b=0
XRU76 t075__t1 t076__t1 vsubs rppd w=2u l=3.43u m=1 b=0
XRU77 t076__t0 t077__t1 vsubs rppd w=2u l=3.43u m=1 b=0
XRU78 t077__t0 t078__t1 vsubs rppd w=2u l=3.43u m=1 b=0
XRU79 t078__t0 t079__t1 vsubs rppd w=2u l=3.43u m=1 b=0
XRU80 t079__t0 t080__t1 vsubs rppd w=2u l=3.43u m=1 b=0
XRU81 t080__t0 t081__t1 vsubs rppd w=2u l=3.43u m=1 b=0
XRU82 t081__t0 t082__t1 vsubs rppd w=2u l=3.43u m=1 b=0
XRU83 t082__t0 t083__t1 vsubs rppd w=2u l=3.43u m=1 b=0
XRU84 t083__t0 t084__t1 vsubs rppd w=2u l=3.43u m=1 b=0
XRU85 t084__t0 t085__t1 vsubs rppd w=2u l=3.43u m=1 b=0
XRU86 t085__t0 t086__t1 vsubs rppd w=2u l=3.43u m=1 b=0
XRU87 t086__t0 t087__t1 vsubs rppd w=2u l=3.43u m=1 b=0
XRU88 t087__t0 t088__t1 vsubs rppd w=2u l=3.43u m=1 b=0
XRU89 t088__t0 t089__t1 vsubs rppd w=2u l=3.43u m=1 b=0
XRU90 t089__t0 t090__t1 vsubs rppd w=2u l=3.43u m=1 b=0
XRU91 t090__t0 t091__t0 vsubs rppd w=2u l=3.43u m=1 b=0
XRU92 t091__t1 t092__t0 vsubs rppd w=2u l=3.43u m=1 b=0
XRU93 t092__t1 t093__t0 vsubs rppd w=2u l=3.43u m=1 b=0
XRU94 t093__t1 t094__t0 vsubs rppd w=2u l=3.43u m=1 b=0
XRU95 t094__t1 t095__t0 vsubs rppd w=2u l=3.43u m=1 b=0
XRU96 t095__t1 t096__t0 vsubs rppd w=2u l=3.43u m=1 b=0
XRU97 t096__t1 t097__t0 vsubs rppd w=2u l=3.43u m=1 b=0
XRU98 t097__t1 t098__t0 vsubs rppd w=2u l=3.43u m=1 b=0
XRU99 t098__t1 t099__t0 vsubs rppd w=2u l=3.43u m=1 b=0
XRU100 t099__t1 t100__t0 vsubs rppd w=2u l=3.43u m=1 b=0
XRU101 t100__t1 t101__t0 vsubs rppd w=2u l=3.43u m=1 b=0
XRU102 t101__t1 t102__t0 vsubs rppd w=2u l=3.43u m=1 b=0
XRU103 t102__t1 t103__t0 vsubs rppd w=2u l=3.43u m=1 b=0
XRU104 t103__t1 t104__t0 vsubs rppd w=2u l=3.43u m=1 b=0
XRU105 t104__t1 t105__t0 vsubs rppd w=2u l=3.43u m=1 b=0
XRU106 t105__t1 t106__t1 vsubs rppd w=2u l=3.43u m=1 b=0
XRU107 t106__t0 t107__t1 vsubs rppd w=2u l=3.43u m=1 b=0
XRU108 t107__t0 t108__t1 vsubs rppd w=2u l=3.43u m=1 b=0
XRU109 t108__t0 t109__t1 vsubs rppd w=2u l=3.43u m=1 b=0
XRU110 t109__t0 t110__t1 vsubs rppd w=2u l=3.43u m=1 b=0
XRU111 t110__t0 t111__t1 vsubs rppd w=2u l=3.43u m=1 b=0
XRU112 t111__t0 t112__t1 vsubs rppd w=2u l=3.43u m=1 b=0
XRU113 t112__t0 t113__t1 vsubs rppd w=2u l=3.43u m=1 b=0
XRU114 t113__t0 t114__t1 vsubs rppd w=2u l=3.43u m=1 b=0
XRU115 t114__t0 t115__t1 vsubs rppd w=2u l=3.43u m=1 b=0
XRU116 t115__t0 t116__t1 vsubs rppd w=2u l=3.43u m=1 b=0
XRU117 t116__t0 t117__t1 vsubs rppd w=2u l=3.43u m=1 b=0
XRU118 t117__t0 t118__t1 vsubs rppd w=2u l=3.43u m=1 b=0
XRU119 t118__t0 t119__t1 vsubs rppd w=2u l=3.43u m=1 b=0
XRU120 t119__t0 t120__t1 vsubs rppd w=2u l=3.43u m=1 b=0
XRU121 t120__t0 t121__t0 vsubs rppd w=2u l=3.43u m=1 b=0
XRU122 t121__t1 t122__t0 vsubs rppd w=2u l=3.43u m=1 b=0
XRU123 t122__t1 t123__t0 vsubs rppd w=2u l=3.43u m=1 b=0
XRU124 t123__t1 t124__t0 vsubs rppd w=2u l=3.43u m=1 b=0
XRU125 t124__t1 t125__t0 vsubs rppd w=2u l=3.43u m=1 b=0
XRU126 t125__t1 t126__t0 vsubs rppd w=2u l=3.43u m=1 b=0
XRU127 t126__t1 tn0__t8 vsubs rppd w=2u l=3.43u m=1 b=0
XRU128 tn0__t12 t128__t0 vsubs rppd w=2u l=3.43u m=1 b=0
XRU129 t128__t1 t129__t0 vsubs rppd w=2u l=3.43u m=1 b=0
XRU130 t129__t1 t130__t0 vsubs rppd w=2u l=3.43u m=1 b=0
XRU131 t130__t1 t131__t0 vsubs rppd w=2u l=3.43u m=1 b=0
XRU132 t131__t1 t132__t0 vsubs rppd w=2u l=3.43u m=1 b=0
XRU133 t132__t1 t133__t0 vsubs rppd w=2u l=3.43u m=1 b=0
XRU134 t133__t1 t134__t0 vsubs rppd w=2u l=3.43u m=1 b=0
XRU135 t134__t1 t135__t1 vsubs rppd w=2u l=3.43u m=1 b=0
XRU136 t135__t0 t136__t1 vsubs rppd w=2u l=3.43u m=1 b=0
XRU137 t136__t0 t137__t1 vsubs rppd w=2u l=3.43u m=1 b=0
XRU138 t137__t0 t138__t1 vsubs rppd w=2u l=3.43u m=1 b=0
XRU139 t138__t0 t139__t1 vsubs rppd w=2u l=3.43u m=1 b=0
XRU140 t139__t0 t140__t1 vsubs rppd w=2u l=3.43u m=1 b=0
XRU141 t140__t0 t141__t1 vsubs rppd w=2u l=3.43u m=1 b=0
XRU142 t141__t0 t142__t1 vsubs rppd w=2u l=3.43u m=1 b=0
XRU143 t142__t0 t143__t1 vsubs rppd w=2u l=3.43u m=1 b=0
XRU144 t143__t0 t144__t1 vsubs rppd w=2u l=3.43u m=1 b=0
XRU145 t144__t0 t145__t1 vsubs rppd w=2u l=3.43u m=1 b=0
XRU146 t145__t0 t146__t1 vsubs rppd w=2u l=3.43u m=1 b=0
XRU147 t146__t0 t147__t1 vsubs rppd w=2u l=3.43u m=1 b=0
XRU148 t147__t0 t148__t1 vsubs rppd w=2u l=3.43u m=1 b=0
XRU149 t148__t0 t149__t1 vsubs rppd w=2u l=3.43u m=1 b=0
XRU150 t149__t0 t150__t1 vsubs rppd w=2u l=3.43u m=1 b=0
XRU151 t150__t0 t151__t0 vsubs rppd w=2u l=3.43u m=1 b=0
XRU152 t151__t1 t152__t0 vsubs rppd w=2u l=3.43u m=1 b=0
XRU153 t152__t1 t153__t0 vsubs rppd w=2u l=3.43u m=1 b=0
XRU154 t153__t1 t154__t0 vsubs rppd w=2u l=3.43u m=1 b=0
XRU155 t154__t1 t155__t0 vsubs rppd w=2u l=3.43u m=1 b=0
XRU156 t155__t1 t156__t0 vsubs rppd w=2u l=3.43u m=1 b=0
XRU157 t156__t1 t157__t0 vsubs rppd w=2u l=3.43u m=1 b=0
XRU158 t157__t1 t158__t0 vsubs rppd w=2u l=3.43u m=1 b=0
XRU159 t158__t1 t159__t0 vsubs rppd w=2u l=3.43u m=1 b=0
XRU160 t159__t1 t160__t0 vsubs rppd w=2u l=3.43u m=1 b=0
XRU161 t160__t1 t161__t0 vsubs rppd w=2u l=3.43u m=1 b=0
XRU162 t161__t1 t162__t0 vsubs rppd w=2u l=3.43u m=1 b=0
XRU163 t162__t1 t163__t0 vsubs rppd w=2u l=3.43u m=1 b=0
XRU164 t163__t1 t164__t0 vsubs rppd w=2u l=3.43u m=1 b=0
XRU165 t164__t1 t165__t0 vsubs rppd w=2u l=3.43u m=1 b=0
XRU166 t165__t1 t166__t1 vsubs rppd w=2u l=3.43u m=1 b=0
XRU167 t166__t0 t167__t1 vsubs rppd w=2u l=3.43u m=1 b=0
XRU168 t167__t0 t168__t1 vsubs rppd w=2u l=3.43u m=1 b=0
XRU169 t168__t0 t169__t1 vsubs rppd w=2u l=3.43u m=1 b=0
XRU170 t169__t0 t170__t1 vsubs rppd w=2u l=3.43u m=1 b=0
XRU171 t170__t0 t171__t1 vsubs rppd w=2u l=3.43u m=1 b=0
XRU172 t171__t0 t172__t1 vsubs rppd w=2u l=3.43u m=1 b=0
XRU173 t172__t0 t173__t1 vsubs rppd w=2u l=3.43u m=1 b=0
XRU174 t173__t0 t174__t1 vsubs rppd w=2u l=3.43u m=1 b=0
XRU175 t174__t0 t175__t1 vsubs rppd w=2u l=3.43u m=1 b=0
XRU176 t175__t0 t176__t1 vsubs rppd w=2u l=3.43u m=1 b=0
XRU177 t176__t0 t177__t1 vsubs rppd w=2u l=3.43u m=1 b=0
XRU178 t177__t0 t178__t1 vsubs rppd w=2u l=3.43u m=1 b=0
XRU179 t178__t0 t179__t1 vsubs rppd w=2u l=3.43u m=1 b=0
XRU180 t179__t0 t180__t1 vsubs rppd w=2u l=3.43u m=1 b=0
XRU181 t180__t0 t181__t0 vsubs rppd w=2u l=3.43u m=1 b=0
XRU182 t181__t1 t182__t0 vsubs rppd w=2u l=3.43u m=1 b=0
XRU183 t182__t1 t183__t0 vsubs rppd w=2u l=3.43u m=1 b=0
XRU184 t183__t1 t184__t0 vsubs rppd w=2u l=3.43u m=1 b=0
XRU185 t184__t1 t185__t0 vsubs rppd w=2u l=3.43u m=1 b=0
XRU186 t185__t1 t186__t0 vsubs rppd w=2u l=3.43u m=1 b=0
XRU187 t186__t1 t187__t0 vsubs rppd w=2u l=3.43u m=1 b=0
XRU188 t187__t1 t188__t0 vsubs rppd w=2u l=3.43u m=1 b=0
XRU189 t188__t1 t189__t0 vsubs rppd w=2u l=3.43u m=1 b=0
XRU190 t189__t1 t190__t0 vsubs rppd w=2u l=3.43u m=1 b=0
XRU191 t190__t1 t191__t0 vsubs rppd w=2u l=3.43u m=1 b=0
XRU192 t191__t1 t192__t0 vsubs rppd w=2u l=3.43u m=1 b=0
XRU193 t192__t1 t193__t0 vsubs rppd w=2u l=3.43u m=1 b=0
XRU194 t193__t1 t194__t0 vsubs rppd w=2u l=3.43u m=1 b=0
XRU195 t194__t1 t195__t1 vsubs rppd w=2u l=3.43u m=1 b=0
XRU196 t195__t0 t196__t1 vsubs rppd w=2u l=3.43u m=1 b=0
XRU197 t196__t0 t197__t1 vsubs rppd w=2u l=3.43u m=1 b=0
XRU198 t197__t0 t198__t1 vsubs rppd w=2u l=3.43u m=1 b=0
XRU199 t198__t0 t199__t1 vsubs rppd w=2u l=3.43u m=1 b=0
XRU200 t199__t0 t200__t1 vsubs rppd w=2u l=3.43u m=1 b=0
XRU201 t200__t0 t201__t1 vsubs rppd w=2u l=3.43u m=1 b=0
XRU202 t201__t0 t202__t1 vsubs rppd w=2u l=3.43u m=1 b=0
XRU203 t202__t0 t203__t1 vsubs rppd w=2u l=3.43u m=1 b=0
XRU204 t203__t0 t204__t1 vsubs rppd w=2u l=3.43u m=1 b=0
XRU205 t204__t0 t205__t1 vsubs rppd w=2u l=3.43u m=1 b=0
XRU206 t205__t0 t206__t1 vsubs rppd w=2u l=3.43u m=1 b=0
XRU207 t206__t0 t207__t1 vsubs rppd w=2u l=3.43u m=1 b=0
XRU208 t207__t0 t208__t1 vsubs rppd w=2u l=3.43u m=1 b=0
XRU209 t208__t0 t209__t1 vsubs rppd w=2u l=3.43u m=1 b=0
XRU210 t209__t0 t210__t1 vsubs rppd w=2u l=3.43u m=1 b=0
XRU211 t210__t0 t211__t0 vsubs rppd w=2u l=3.43u m=1 b=0
XRU212 t211__t1 t212__t0 vsubs rppd w=2u l=3.43u m=1 b=0
XRU213 t212__t1 t213__t0 vsubs rppd w=2u l=3.43u m=1 b=0
XRU214 t213__t1 t214__t0 vsubs rppd w=2u l=3.43u m=1 b=0
XRU215 t214__t1 t215__t0 vsubs rppd w=2u l=3.43u m=1 b=0
XRU216 t215__t1 t216__t0 vsubs rppd w=2u l=3.43u m=1 b=0
XRU217 t216__t1 t217__t0 vsubs rppd w=2u l=3.43u m=1 b=0
XRU218 t217__t1 t218__t0 vsubs rppd w=2u l=3.43u m=1 b=0
XRU219 t218__t1 t219__t0 vsubs rppd w=2u l=3.43u m=1 b=0
XRU220 t219__t1 t220__t0 vsubs rppd w=2u l=3.43u m=1 b=0
XRU221 t220__t1 t221__t0 vsubs rppd w=2u l=3.43u m=1 b=0
XRU222 t221__t1 t222__t0 vsubs rppd w=2u l=3.43u m=1 b=0
XRU223 t222__t1 t223__t0 vsubs rppd w=2u l=3.43u m=1 b=0
XRU224 t223__t1 t224__t0 vsubs rppd w=2u l=3.43u m=1 b=0
XRU225 t224__t1 t225__t0 vsubs rppd w=2u l=3.43u m=1 b=0
XRU226 t225__t1 t226__t1 vsubs rppd w=2u l=3.43u m=1 b=0
XRU227 t226__t0 t227__t1 vsubs rppd w=2u l=3.43u m=1 b=0
XRU228 t227__t0 t228__t1 vsubs rppd w=2u l=3.43u m=1 b=0
XRU229 t228__t0 t229__t1 vsubs rppd w=2u l=3.43u m=1 b=0
XRU230 t229__t0 t230__t1 vsubs rppd w=2u l=3.43u m=1 b=0
XRU231 t230__t0 t231__t1 vsubs rppd w=2u l=3.43u m=1 b=0
XRU232 t231__t0 t232__t1 vsubs rppd w=2u l=3.43u m=1 b=0
XRU233 t232__t0 t233__t1 vsubs rppd w=2u l=3.43u m=1 b=0
XRU234 t233__t0 t234__t1 vsubs rppd w=2u l=3.43u m=1 b=0
XRU235 t234__t0 t235__t1 vsubs rppd w=2u l=3.43u m=1 b=0
XRU236 t235__t0 t236__t1 vsubs rppd w=2u l=3.43u m=1 b=0
XRU237 t236__t0 t237__t1 vsubs rppd w=2u l=3.43u m=1 b=0
XRU238 t237__t0 t238__t1 vsubs rppd w=2u l=3.43u m=1 b=0
XRU239 t238__t0 t239__t1 vsubs rppd w=2u l=3.43u m=1 b=0
XRU240 t239__t0 t240__t0 vsubs rppd w=2u l=3.43u m=1 b=0
XRU241 t240__t1 t241__t0 vsubs rppd w=2u l=3.43u m=1 b=0
XRU242 t241__t1 t242__t0 vsubs rppd w=2u l=3.43u m=1 b=0
XRU243 t242__t1 t243__t0 vsubs rppd w=2u l=3.43u m=1 b=0
XRU244 t243__t1 t244__t0 vsubs rppd w=2u l=3.43u m=1 b=0
XRU245 t244__t1 t245__t0 vsubs rppd w=2u l=3.43u m=1 b=0
XRU246 t245__t1 t246__t0 vsubs rppd w=2u l=3.43u m=1 b=0
XRU247 t246__t1 t247__t0 vsubs rppd w=2u l=3.43u m=1 b=0
XRU248 t247__t1 t248__t0 vsubs rppd w=2u l=3.43u m=1 b=0
XRU249 t248__t1 t249__t0 vsubs rppd w=2u l=3.43u m=1 b=0
XRU250 t249__t1 t250__t0 vsubs rppd w=2u l=3.43u m=1 b=0
XRU251 t250__t1 t251__t0 vsubs rppd w=2u l=3.43u m=1 b=0
XRU252 t251__t1 t252__t0 vsubs rppd w=2u l=3.43u m=1 b=0
XRU253 t252__t1 t253__t0 vsubs rppd w=2u l=3.43u m=1 b=0
XRU254 t253__t1 t254__t0 vsubs rppd w=2u l=3.43u m=1 b=0
XRU255 t254__t1 cb3__t0 vsubs rppd w=2u l=3.43u m=1 b=0
XQ1 sns1 sns1 vss vss npn13G2 Nx=1
XQ2 cb2 cb2 vss vss npn13G2 Nx=8
XQ3 cb3 cb3 vss vss npn13G2 Nx=1

* Wire parasitics
rcb2_t0 cb2__t0 cb2 23.0085
ccb2 cb2 vsubs 7.410176e-15
rcb3_t0 cb3__t0 cb3 38.9336
ccb3 cb3 vsubs 1.1944554e-14
rd1_t0 d1__t0 d1 7.54922674567
rd1_t1 d1__t1 d1 7.54922674567
rd1_t2 d1__t2 d1 8.77536973712
rd1_t3 d1__t3 d1 22.2013767715
cd1 d1 vsubs 1.6632756e-14
rd2_t0 d2__t0 d2 9.66177600915
rd2_t1 d2__t1 d2 8.56771381538
rd2_t2 d2__t2 d2 25.3121963601
rd2_t3 d2__t3 d2 8.56771381538
cd2 d2 vsubs 1.8465821e-14
rdet_t0 det__t0 det 7.2824560321
rdet_t1 det__t1 det 8.58380770088
rdet_t2 det__t2 det 4.66093626702
cdet det vsubs 5.249053e-15
rfb_t0 fb__t0 fb 8.46865607169
rfb_t1 fb__t1 fb 28.2528223622
rfb_t2 fb__t2 fb 14.6334379439
rfb_t3 fb__t3 fb 12.015433778
rfb_t4 fb__t4 fb 4.43266838666
rfb_t5 fb__t5 fb 7.84600373357
rfb_t6 fb__t6 fb 5.73911789424
rfb_t7 fb__t7 fb 24.7452236486
rfb_t8 fb__t8 fb 9.99146253243
rfb_t9 fb__t9 fb 15.2236736488
cfb fb vsubs 3.6393516e-14
rsns1_t0 sns1__t0 sns1 54.2966755282
rsns1_t1 sns1__t1 sns1 37.0964878587
rsns1_t2 sns1__t2 sns1 20.9303366131
csns1 sns1 vsubs 2.8859197e-14
rsns2_t0 sns2__t0 sns2 22.5415775993
rsns2_t1 sns2__t1 sns2 4.09368781645
rsns2_t2 sns2__t2 sns2 8.51103484455
rsns2_t3 sns2__t3 sns2 11.5835997397
csns2 sns2 vsubs 1.3888551e-14
rpn_t0 pn__t0 pn 1.91702573615
rpn_t1 pn__t1 pn 7.90409959717
rpn_t2 pn__t2 pn 7.90409959717
rpn_t3 pn__t3 pn 16.3790750695
cpn pn vsubs 1.131071e-14
rtn0_t0 tn0__t0 tn0 2.11437307947
rtn0_t1 tn0__t1 tn0 2.11437307947
rtn0_t2 tn0__t2 tn0 3.64129851262
rtn0_t3 tn0__t3 tn0 4.27764381987
rtn0_t4 tn0__t4 tn0 4.26794100965
rtn0_t5 tn0__t5 tn0 1.22032207139
rtn0_t6 tn0__t6 tn0 1.41433371914
rtn0_t7 tn0__t7 tn0 2.1083668847
rtn0_t8 tn0__t8 tn0 1.93726691506
rtn0_t9 tn0__t9 tn0 0.695110670243
rtn0_t10 tn0__t10 tn0 1.65770478058
rtn0_t11 tn0__t11 tn0 0.786185842119
rtn0_t12 tn0__t12 tn0 2.12935702113
rtn0_t13 tn0__t13 tn0 1.66533712449
rtn0_t14 tn0__t14 tn0 1.06265803038
rtn0_t15 tn0__t15 tn0 1.1244274397
ctn0 tn0 vsubs 2.4934244e-14
rt002_t0 t002__t0 t002 0.0275
rt002_t1 t002__t1 t002 0.0275
ct002 t002 vsubs 3.43837e-16
rt004_t0 t004__t0 t004 0.0275
rt004_t1 t004__t1 t004 0.0275
ct004 t004 vsubs 3.43837e-16
rt005_t0 t005__t0 t005 0.0275
rt005_t1 t005__t1 t005 0.0275
ct005 t005 vsubs 3.43837e-16
rt006_t0 t006__t0 t006 0.0275
rt006_t1 t006__t1 t006 0.0275
ct006 t006 vsubs 3.43837e-16
rt008_t0 t008__t0 t008 0.0275
rt008_t1 t008__t1 t008 0.0275
ct008 t008 vsubs 3.43837e-16
rt009_t0 t009__t0 t009 0.0275
rt009_t1 t009__t1 t009 0.0275
ct009 t009 vsubs 3.43837e-16
rt010_t0 t010__t0 t010 0.0275
rt010_t1 t010__t1 t010 0.0275
ct010 t010 vsubs 3.43837e-16
rt011_t0 t011__t0 t011 0.0275
rt011_t1 t011__t1 t011 0.0275
ct011 t011 vsubs 3.43837e-16
rt012_t0 t012__t0 t012 0.0275
rt012_t1 t012__t1 t012 0.0275
ct012 t012 vsubs 3.43837e-16
rt013_t0 t013__t0 t013 0.0275
rt013_t1 t013__t1 t013 0.0275
ct013 t013 vsubs 3.43837e-16
rt014_t0 t014__t0 t014 0.0275
rt014_t1 t014__t1 t014 0.0275
ct014 t014 vsubs 3.43837e-16
rt016_t0 t016__t0 t016 0.0275
rt016_t1 t016__t1 t016 0.0275
ct016 t016 vsubs 3.85855e-16
rt017_t0 t017__t0 t017 0.0275
rt017_t1 t017__t1 t017 0.0275
ct017 t017 vsubs 3.85855e-16
rt018_t0 t018__t0 t018 0.0275
rt018_t1 t018__t1 t018 0.0275
ct018 t018 vsubs 3.85855e-16
rt019_t0 t019__t0 t019 0.0275
rt019_t1 t019__t1 t019 0.0275
ct019 t019 vsubs 3.85855e-16
rt020_t0 t020__t0 t020 0.0275
rt020_t1 t020__t1 t020 0.0275
ct020 t020 vsubs 3.85855e-16
rt021_t0 t021__t0 t021 0.0275
rt021_t1 t021__t1 t021 0.0275
ct021 t021 vsubs 3.85855e-16
rt022_t0 t022__t0 t022 0.0275
rt022_t1 t022__t1 t022 0.0275
ct022 t022 vsubs 3.85855e-16
rt023_t0 t023__t0 t023 0.0275
rt023_t1 t023__t1 t023 0.0275
ct023 t023 vsubs 3.85855e-16
rt024_t0 t024__t0 t024 0.0275
rt024_t1 t024__t1 t024 0.0275
ct024 t024 vsubs 3.85855e-16
rt025_t0 t025__t0 t025 0.0275
rt025_t1 t025__t1 t025 0.0275
ct025 t025 vsubs 3.85855e-16
rt026_t0 t026__t0 t026 0.0275
rt026_t1 t026__t1 t026 0.0275
ct026 t026 vsubs 3.85855e-16
rt027_t0 t027__t0 t027 0.0275
rt027_t1 t027__t1 t027 0.0275
ct027 t027 vsubs 3.85855e-16
rt028_t0 t028__t0 t028 0.0275
rt028_t1 t028__t1 t028 0.0275
ct028 t028 vsubs 3.85855e-16
rt029_t0 t029__t0 t029 0.0275
rt029_t1 t029__t1 t029 0.0275
ct029 t029 vsubs 3.85855e-16
rt030_t0 t030__t0 t030 0.561
rt030_t1 t030__t1 t030 0.561
ct030 t030 vsubs 5.3264e-16
rt032_t0 t032__t0 t032 0.0275
rt032_t1 t032__t1 t032 0.0275
ct032 t032 vsubs 3.43837e-16
rt033_t0 t033__t0 t033 0.0275
rt033_t1 t033__t1 t033 0.0275
ct033 t033 vsubs 3.43837e-16
rt034_t0 t034__t0 t034 0.0275
rt034_t1 t034__t1 t034 0.0275
ct034 t034 vsubs 3.43837e-16
rt035_t0 t035__t0 t035 0.0275
rt035_t1 t035__t1 t035 0.0275
ct035 t035 vsubs 3.43837e-16
rt036_t0 t036__t0 t036 0.0275
rt036_t1 t036__t1 t036 0.0275
ct036 t036 vsubs 3.43837e-16
rt037_t0 t037__t0 t037 0.0275
rt037_t1 t037__t1 t037 0.0275
ct037 t037 vsubs 3.43837e-16
rt038_t0 t038__t0 t038 0.0275
rt038_t1 t038__t1 t038 0.0275
ct038 t038 vsubs 3.43837e-16
rt039_t0 t039__t0 t039 0.0275
rt039_t1 t039__t1 t039 0.0275
ct039 t039 vsubs 3.43837e-16
rt040_t0 t040__t0 t040 0.0275
rt040_t1 t040__t1 t040 0.0275
ct040 t040 vsubs 3.43837e-16
rt041_t0 t041__t0 t041 0.0275
rt041_t1 t041__t1 t041 0.0275
ct041 t041 vsubs 3.43837e-16
rt042_t0 t042__t0 t042 0.0275
rt042_t1 t042__t1 t042 0.0275
ct042 t042 vsubs 3.43837e-16
rt043_t0 t043__t0 t043 0.0275
rt043_t1 t043__t1 t043 0.0275
ct043 t043 vsubs 3.43837e-16
rt044_t0 t044__t0 t044 0.0275
rt044_t1 t044__t1 t044 0.0275
ct044 t044 vsubs 3.43837e-16
rt045_t0 t045__t0 t045 0.561
rt045_t1 t045__t1 t045 0.561
ct045 t045 vsubs 5.07254e-16
rt046_t0 t046__t0 t046 0.0275
rt046_t1 t046__t1 t046 0.0275
ct046 t046 vsubs 3.85855e-16
rt047_t0 t047__t0 t047 0.0275
rt047_t1 t047__t1 t047 0.0275
ct047 t047 vsubs 3.85855e-16
rt048_t0 t048__t0 t048 0.0275
rt048_t1 t048__t1 t048 0.0275
ct048 t048 vsubs 3.85855e-16
rt049_t0 t049__t0 t049 0.0275
rt049_t1 t049__t1 t049 0.0275
ct049 t049 vsubs 3.85855e-16
rt050_t0 t050__t0 t050 0.0275
rt050_t1 t050__t1 t050 0.0275
ct050 t050 vsubs 3.85855e-16
rt051_t0 t051__t0 t051 0.0275
rt051_t1 t051__t1 t051 0.0275
ct051 t051 vsubs 3.85855e-16
rt052_t0 t052__t0 t052 0.0275
rt052_t1 t052__t1 t052 0.0275
ct052 t052 vsubs 3.85855e-16
rt053_t0 t053__t0 t053 0.0275
rt053_t1 t053__t1 t053 0.0275
ct053 t053 vsubs 3.85855e-16
rt054_t0 t054__t0 t054 0.0275
rt054_t1 t054__t1 t054 0.0275
ct054 t054 vsubs 3.85855e-16
rt055_t0 t055__t0 t055 0.0275
rt055_t1 t055__t1 t055 0.0275
ct055 t055 vsubs 3.85855e-16
rt056_t0 t056__t0 t056 0.0275
rt056_t1 t056__t1 t056 0.0275
ct056 t056 vsubs 3.85855e-16
rt057_t0 t057__t0 t057 0.0275
rt057_t1 t057__t1 t057 0.0275
ct057 t057 vsubs 3.85855e-16
rt058_t0 t058__t0 t058 0.0275
rt058_t1 t058__t1 t058 0.0275
ct058 t058 vsubs 3.85855e-16
rt059_t0 t059__t0 t059 0.0275
rt059_t1 t059__t1 t059 0.0275
ct059 t059 vsubs 3.22828e-16
rt060_t0 t060__t0 t060 0.561
rt060_t1 t060__t1 t060 0.561
ct060 t060 vsubs 5.3264e-16
rt061_t0 t061__t0 t061 0.0275
rt061_t1 t061__t1 t061 0.0275
ct061 t061 vsubs 3.29831e-16
rt062_t0 t062__t0 t062 0.0275
rt062_t1 t062__t1 t062 0.0275
ct062 t062 vsubs 3.43837e-16
rt064_t0 t064__t0 t064 0.0275
rt064_t1 t064__t1 t064 0.0275
ct064 t064 vsubs 3.85855e-16
rt065_t0 t065__t0 t065 0.0275
rt065_t1 t065__t1 t065 0.0275
ct065 t065 vsubs 3.85855e-16
rt066_t0 t066__t0 t066 0.0275
rt066_t1 t066__t1 t066 0.0275
ct066 t066 vsubs 3.85855e-16
rt067_t0 t067__t0 t067 0.0275
rt067_t1 t067__t1 t067 0.0275
ct067 t067 vsubs 3.85855e-16
rt068_t0 t068__t0 t068 0.0275
rt068_t1 t068__t1 t068 0.0275
ct068 t068 vsubs 3.85855e-16
rt069_t0 t069__t0 t069 0.0275
rt069_t1 t069__t1 t069 0.0275
ct069 t069 vsubs 3.85855e-16
rt070_t0 t070__t0 t070 0.0275
rt070_t1 t070__t1 t070 0.0275
ct070 t070 vsubs 3.85855e-16
rt071_t0 t071__t0 t071 0.0275
rt071_t1 t071__t1 t071 0.0275
ct071 t071 vsubs 3.85855e-16
rt072_t0 t072__t0 t072 0.0275
rt072_t1 t072__t1 t072 0.0275
ct072 t072 vsubs 3.85855e-16
rt073_t0 t073__t0 t073 0.0275
rt073_t1 t073__t1 t073 0.0275
ct073 t073 vsubs 3.85855e-16
rt074_t0 t074__t0 t074 0.0275
rt074_t1 t074__t1 t074 0.0275
ct074 t074 vsubs 3.85855e-16
rt075_t0 t075__t0 t075 0.561
rt075_t1 t075__t1 t075 0.561
ct075 t075 vsubs 5.3264e-16
rt076_t0 t076__t0 t076 0.0275
rt076_t1 t076__t1 t076 0.0275
ct076 t076 vsubs 3.85855e-16
rt077_t0 t077__t0 t077 0.0275
rt077_t1 t077__t1 t077 0.0275
ct077 t077 vsubs 3.85855e-16
rt078_t0 t078__t0 t078 0.0275
rt078_t1 t078__t1 t078 0.0275
ct078 t078 vsubs 3.85855e-16
rt079_t0 t079__t0 t079 0.0275
rt079_t1 t079__t1 t079 0.0275
ct079 t079 vsubs 3.85855e-16
rt080_t0 t080__t0 t080 0.0275
rt080_t1 t080__t1 t080 0.0275
ct080 t080 vsubs 3.85855e-16
rt081_t0 t081__t0 t081 0.0275
rt081_t1 t081__t1 t081 0.0275
ct081 t081 vsubs 3.85855e-16
rt082_t0 t082__t0 t082 0.0275
rt082_t1 t082__t1 t082 0.0275
ct082 t082 vsubs 3.85855e-16
rt083_t0 t083__t0 t083 0.0275
rt083_t1 t083__t1 t083 0.0275
ct083 t083 vsubs 3.85855e-16
rt084_t0 t084__t0 t084 0.0275
rt084_t1 t084__t1 t084 0.0275
ct084 t084 vsubs 3.85855e-16
rt085_t0 t085__t0 t085 0.0275
rt085_t1 t085__t1 t085 0.0275
ct085 t085 vsubs 3.85855e-16
rt086_t0 t086__t0 t086 0.0275
rt086_t1 t086__t1 t086 0.0275
ct086 t086 vsubs 3.85855e-16
rt087_t0 t087__t0 t087 0.0275
rt087_t1 t087__t1 t087 0.0275
ct087 t087 vsubs 3.22828e-16
rt088_t0 t088__t0 t088 0.0275
rt088_t1 t088__t1 t088 0.0275
ct088 t088 vsubs 3.85855e-16
rt089_t0 t089__t0 t089 0.0275
rt089_t1 t089__t1 t089 0.0275
ct089 t089 vsubs 3.85855e-16
rt090_t0 t090__t0 t090 0.561
rt090_t1 t090__t1 t090 0.561
ct090 t090 vsubs 5.3264e-16
rt091_t0 t091__t0 t091 0.0275
rt091_t1 t091__t1 t091 0.0275
ct091 t091 vsubs 3.85855e-16
rt092_t0 t092__t0 t092 0.0275
rt092_t1 t092__t1 t092 0.0275
ct092 t092 vsubs 3.85855e-16
rt093_t0 t093__t0 t093 0.0275
rt093_t1 t093__t1 t093 0.0275
ct093 t093 vsubs 3.22828e-16
rt094_t0 t094__t0 t094 0.0275
rt094_t1 t094__t1 t094 0.0275
ct094 t094 vsubs 3.85855e-16
rt095_t0 t095__t0 t095 0.0275
rt095_t1 t095__t1 t095 0.0275
ct095 t095 vsubs 3.85855e-16
rt096_t0 t096__t0 t096 0.0275
rt096_t1 t096__t1 t096 0.0275
ct096 t096 vsubs 3.85855e-16
rt097_t0 t097__t0 t097 0.0275
rt097_t1 t097__t1 t097 0.0275
ct097 t097 vsubs 3.85855e-16
rt098_t0 t098__t0 t098 0.0275
rt098_t1 t098__t1 t098 0.0275
ct098 t098 vsubs 3.85855e-16
rt099_t0 t099__t0 t099 0.0275
rt099_t1 t099__t1 t099 0.0275
ct099 t099 vsubs 3.85855e-16
rt100_t0 t100__t0 t100 0.0275
rt100_t1 t100__t1 t100 0.0275
ct100 t100 vsubs 3.85855e-16
rt101_t0 t101__t0 t101 0.0275
rt101_t1 t101__t1 t101 0.0275
ct101 t101 vsubs 3.85855e-16
rt102_t0 t102__t0 t102 0.0275
rt102_t1 t102__t1 t102 0.0275
ct102 t102 vsubs 3.85855e-16
rt103_t0 t103__t0 t103 0.0275
rt103_t1 t103__t1 t103 0.0275
ct103 t103 vsubs 3.85855e-16
rt104_t0 t104__t0 t104 0.0275
rt104_t1 t104__t1 t104 0.0275
ct104 t104 vsubs 3.85855e-16
rt105_t0 t105__t0 t105 0.561
rt105_t1 t105__t1 t105 0.561
ct105 t105 vsubs 5.3264e-16
rt106_t0 t106__t0 t106 0.0275
rt106_t1 t106__t1 t106 0.0275
ct106 t106 vsubs 3.85855e-16
rt107_t0 t107__t0 t107 0.0275
rt107_t1 t107__t1 t107 0.0275
ct107 t107 vsubs 3.85855e-16
rt108_t0 t108__t0 t108 0.0275
rt108_t1 t108__t1 t108 0.0275
ct108 t108 vsubs 3.85855e-16
rt109_t0 t109__t0 t109 0.0275
rt109_t1 t109__t1 t109 0.0275
ct109 t109 vsubs 3.85855e-16
rt110_t0 t110__t0 t110 0.0275
rt110_t1 t110__t1 t110 0.0275
ct110 t110 vsubs 3.85855e-16
rt111_t0 t111__t0 t111 0.0275
rt111_t1 t111__t1 t111 0.0275
ct111 t111 vsubs 3.85855e-16
rt112_t0 t112__t0 t112 0.0275
rt112_t1 t112__t1 t112 0.0275
ct112 t112 vsubs 3.85855e-16
rt113_t0 t113__t0 t113 0.0275
rt113_t1 t113__t1 t113 0.0275
ct113 t113 vsubs 3.85855e-16
rt114_t0 t114__t0 t114 0.0275
rt114_t1 t114__t1 t114 0.0275
ct114 t114 vsubs 3.85855e-16
rt115_t0 t115__t0 t115 0.0275
rt115_t1 t115__t1 t115 0.0275
ct115 t115 vsubs 3.85855e-16
rt116_t0 t116__t0 t116 0.0275
rt116_t1 t116__t1 t116 0.0275
ct116 t116 vsubs 3.85855e-16
rt117_t0 t117__t0 t117 0.0275
rt117_t1 t117__t1 t117 0.0275
ct117 t117 vsubs 3.22828e-16
rt118_t0 t118__t0 t118 0.0275
rt118_t1 t118__t1 t118 0.0275
ct118 t118 vsubs 3.85855e-16
rt119_t0 t119__t0 t119 0.0275
rt119_t1 t119__t1 t119 0.0275
ct119 t119 vsubs 3.85855e-16
rt120_t0 t120__t0 t120 0.561
rt120_t1 t120__t1 t120 0.561
ct120 t120 vsubs 5.3264e-16
rt121_t0 t121__t0 t121 0.0275
rt121_t1 t121__t1 t121 0.0275
ct121 t121 vsubs 3.85855e-16
rt122_t0 t122__t0 t122 0.0275
rt122_t1 t122__t1 t122 0.0275
ct122 t122 vsubs 3.85855e-16
rt123_t0 t123__t0 t123 0.0275
rt123_t1 t123__t1 t123 0.0275
ct123 t123 vsubs 3.29831e-16
rt124_t0 t124__t0 t124 0.0275
rt124_t1 t124__t1 t124 0.0275
ct124 t124 vsubs 3.43837e-16
rt125_t0 t125__t0 t125 0.0275
rt125_t1 t125__t1 t125 0.0275
ct125 t125 vsubs 3.43837e-16
rt126_t0 t126__t0 t126 0.0275
rt126_t1 t126__t1 t126 0.0275
ct126 t126 vsubs 3.43837e-16
rt128_t0 t128__t0 t128 0.0275
rt128_t1 t128__t1 t128 0.0275
ct128 t128 vsubs 3.85855e-16
rt129_t0 t129__t0 t129 0.0275
rt129_t1 t129__t1 t129 0.0275
ct129 t129 vsubs 3.85855e-16
rt130_t0 t130__t0 t130 0.0275
rt130_t1 t130__t1 t130 0.0275
ct130 t130 vsubs 3.85855e-16
rt131_t0 t131__t0 t131 0.0275
rt131_t1 t131__t1 t131 0.0275
ct131 t131 vsubs 3.85855e-16
rt132_t0 t132__t0 t132 0.0275
rt132_t1 t132__t1 t132 0.0275
ct132 t132 vsubs 3.85855e-16
rt133_t0 t133__t0 t133 0.0275
rt133_t1 t133__t1 t133 0.0275
ct133 t133 vsubs 3.85855e-16
rt134_t0 t134__t0 t134 0.0275
rt134_t1 t134__t1 t134 0.0275
ct134 t134 vsubs 3.85855e-16
rt135_t0 t135__t0 t135 0.561
rt135_t1 t135__t1 t135 0.561
ct135 t135 vsubs 5.3264e-16
rt136_t0 t136__t0 t136 0.0275
rt136_t1 t136__t1 t136 0.0275
ct136 t136 vsubs 3.85855e-16
rt137_t0 t137__t0 t137 0.0275
rt137_t1 t137__t1 t137 0.0275
ct137 t137 vsubs 3.85855e-16
rt138_t0 t138__t0 t138 0.0275
rt138_t1 t138__t1 t138 0.0275
ct138 t138 vsubs 3.85855e-16
rt139_t0 t139__t0 t139 0.0275
rt139_t1 t139__t1 t139 0.0275
ct139 t139 vsubs 3.85855e-16
rt140_t0 t140__t0 t140 0.0275
rt140_t1 t140__t1 t140 0.0275
ct140 t140 vsubs 3.85855e-16
rt141_t0 t141__t0 t141 0.0275
rt141_t1 t141__t1 t141 0.0275
ct141 t141 vsubs 3.85855e-16
rt142_t0 t142__t0 t142 0.0275
rt142_t1 t142__t1 t142 0.0275
ct142 t142 vsubs 3.85855e-16
rt143_t0 t143__t0 t143 0.0275
rt143_t1 t143__t1 t143 0.0275
ct143 t143 vsubs 3.85855e-16
rt144_t0 t144__t0 t144 0.0275
rt144_t1 t144__t1 t144 0.0275
ct144 t144 vsubs 3.85855e-16
rt145_t0 t145__t0 t145 0.0275
rt145_t1 t145__t1 t145 0.0275
ct145 t145 vsubs 3.85855e-16
rt146_t0 t146__t0 t146 0.0275
rt146_t1 t146__t1 t146 0.0275
ct146 t146 vsubs 3.85855e-16
rt147_t0 t147__t0 t147 0.0275
rt147_t1 t147__t1 t147 0.0275
ct147 t147 vsubs 3.85855e-16
rt148_t0 t148__t0 t148 0.0275
rt148_t1 t148__t1 t148 0.0275
ct148 t148 vsubs 3.85855e-16
rt149_t0 t149__t0 t149 0.0275
rt149_t1 t149__t1 t149 0.0275
ct149 t149 vsubs 3.85855e-16
rt150_t0 t150__t0 t150 0.561
rt150_t1 t150__t1 t150 0.561
ct150 t150 vsubs 5.3264e-16
rt151_t0 t151__t0 t151 0.0275
rt151_t1 t151__t1 t151 0.0275
ct151 t151 vsubs 3.85855e-16
rt152_t0 t152__t0 t152 0.0275
rt152_t1 t152__t1 t152 0.0275
ct152 t152 vsubs 3.85855e-16
rt153_t0 t153__t0 t153 0.0275
rt153_t1 t153__t1 t153 0.0275
ct153 t153 vsubs 3.85855e-16
rt154_t0 t154__t0 t154 0.0275
rt154_t1 t154__t1 t154 0.0275
ct154 t154 vsubs 3.85855e-16
rt155_t0 t155__t0 t155 0.0275
rt155_t1 t155__t1 t155 0.0275
ct155 t155 vsubs 3.85855e-16
rt156_t0 t156__t0 t156 0.0275
rt156_t1 t156__t1 t156 0.0275
ct156 t156 vsubs 3.85855e-16
rt157_t0 t157__t0 t157 0.0275
rt157_t1 t157__t1 t157 0.0275
ct157 t157 vsubs 3.85855e-16
rt158_t0 t158__t0 t158 0.0275
rt158_t1 t158__t1 t158 0.0275
ct158 t158 vsubs 3.85855e-16
rt159_t0 t159__t0 t159 0.0275
rt159_t1 t159__t1 t159 0.0275
ct159 t159 vsubs 3.85855e-16
rt160_t0 t160__t0 t160 0.0275
rt160_t1 t160__t1 t160 0.0275
ct160 t160 vsubs 3.85855e-16
rt161_t0 t161__t0 t161 0.0275
rt161_t1 t161__t1 t161 0.0275
ct161 t161 vsubs 3.85855e-16
rt162_t0 t162__t0 t162 0.0275
rt162_t1 t162__t1 t162 0.0275
ct162 t162 vsubs 3.85855e-16
rt163_t0 t163__t0 t163 0.0275
rt163_t1 t163__t1 t163 0.0275
ct163 t163 vsubs 3.85855e-16
rt164_t0 t164__t0 t164 0.0275
rt164_t1 t164__t1 t164 0.0275
ct164 t164 vsubs 3.85855e-16
rt165_t0 t165__t0 t165 0.561
rt165_t1 t165__t1 t165 0.561
ct165 t165 vsubs 5.3264e-16
rt166_t0 t166__t0 t166 0.0275
rt166_t1 t166__t1 t166 0.0275
ct166 t166 vsubs 3.85855e-16
rt167_t0 t167__t0 t167 0.0275
rt167_t1 t167__t1 t167 0.0275
ct167 t167 vsubs 3.85855e-16
rt168_t0 t168__t0 t168 0.0275
rt168_t1 t168__t1 t168 0.0275
ct168 t168 vsubs 3.85855e-16
rt169_t0 t169__t0 t169 0.0275
rt169_t1 t169__t1 t169 0.0275
ct169 t169 vsubs 3.85855e-16
rt170_t0 t170__t0 t170 0.0275
rt170_t1 t170__t1 t170 0.0275
ct170 t170 vsubs 3.85855e-16
rt171_t0 t171__t0 t171 0.0275
rt171_t1 t171__t1 t171 0.0275
ct171 t171 vsubs 3.85855e-16
rt172_t0 t172__t0 t172 0.0275
rt172_t1 t172__t1 t172 0.0275
ct172 t172 vsubs 3.85855e-16
rt173_t0 t173__t0 t173 0.0275
rt173_t1 t173__t1 t173 0.0275
ct173 t173 vsubs 3.85855e-16
rt174_t0 t174__t0 t174 0.0275
rt174_t1 t174__t1 t174 0.0275
ct174 t174 vsubs 3.85855e-16
rt175_t0 t175__t0 t175 0.0275
rt175_t1 t175__t1 t175 0.0275
ct175 t175 vsubs 3.85855e-16
rt176_t0 t176__t0 t176 0.0275
rt176_t1 t176__t1 t176 0.0275
ct176 t176 vsubs 3.85855e-16
rt177_t0 t177__t0 t177 0.0275
rt177_t1 t177__t1 t177 0.0275
ct177 t177 vsubs 3.85855e-16
rt178_t0 t178__t0 t178 0.0275
rt178_t1 t178__t1 t178 0.0275
ct178 t178 vsubs 3.85855e-16
rt179_t0 t179__t0 t179 0.0275
rt179_t1 t179__t1 t179 0.0275
ct179 t179 vsubs 3.85855e-16
rt180_t0 t180__t0 t180 0.561
rt180_t1 t180__t1 t180 0.561
ct180 t180 vsubs 5.3264e-16
rt181_t0 t181__t0 t181 0.0275
rt181_t1 t181__t1 t181 0.0275
ct181 t181 vsubs 3.85855e-16
rt182_t0 t182__t0 t182 0.0275
rt182_t1 t182__t1 t182 0.0275
ct182 t182 vsubs 3.85855e-16
rt183_t0 t183__t0 t183 0.0275
rt183_t1 t183__t1 t183 0.0275
ct183 t183 vsubs 3.85855e-16
rt184_t0 t184__t0 t184 0.0275
rt184_t1 t184__t1 t184 0.0275
ct184 t184 vsubs 3.85855e-16
rt185_t0 t185__t0 t185 0.0275
rt185_t1 t185__t1 t185 0.0275
ct185 t185 vsubs 3.85855e-16
rt186_t0 t186__t0 t186 0.0275
rt186_t1 t186__t1 t186 0.0275
ct186 t186 vsubs 3.85855e-16
rt187_t0 t187__t0 t187 0.0275
rt187_t1 t187__t1 t187 0.0275
ct187 t187 vsubs 3.85855e-16
rt188_t0 t188__t0 t188 0.0275
rt188_t1 t188__t1 t188 0.0275
ct188 t188 vsubs 3.85855e-16
rt189_t0 t189__t0 t189 0.0275
rt189_t1 t189__t1 t189 0.0275
ct189 t189 vsubs 3.85855e-16
rt190_t0 t190__t0 t190 0.0275
rt190_t1 t190__t1 t190 0.0275
ct190 t190 vsubs 3.85855e-16
rt191_t0 t191__t0 t191 0.0275
rt191_t1 t191__t1 t191 0.0275
ct191 t191 vsubs 3.85855e-16
rt192_t0 t192__t0 t192 0.0275
rt192_t1 t192__t1 t192 0.0275
ct192 t192 vsubs 3.85855e-16
rt193_t0 t193__t0 t193 0.0275
rt193_t1 t193__t1 t193 0.0275
ct193 t193 vsubs 3.85855e-16
rt194_t0 t194__t0 t194 0.0275
rt194_t1 t194__t1 t194 0.0275
ct194 t194 vsubs 3.85855e-16
rt195_t0 t195__t0 t195 0.561
rt195_t1 t195__t1 t195 0.561
ct195 t195 vsubs 5.3264e-16
rt196_t0 t196__t0 t196 0.0275
rt196_t1 t196__t1 t196 0.0275
ct196 t196 vsubs 3.85855e-16
rt197_t0 t197__t0 t197 0.0275
rt197_t1 t197__t1 t197 0.0275
ct197 t197 vsubs 3.85855e-16
rt198_t0 t198__t0 t198 0.0275
rt198_t1 t198__t1 t198 0.0275
ct198 t198 vsubs 3.85855e-16
rt199_t0 t199__t0 t199 0.0275
rt199_t1 t199__t1 t199 0.0275
ct199 t199 vsubs 3.85855e-16
rt200_t0 t200__t0 t200 0.0275
rt200_t1 t200__t1 t200 0.0275
ct200 t200 vsubs 3.85855e-16
rt201_t0 t201__t0 t201 0.0275
rt201_t1 t201__t1 t201 0.0275
ct201 t201 vsubs 3.85855e-16
rt202_t0 t202__t0 t202 0.0275
rt202_t1 t202__t1 t202 0.0275
ct202 t202 vsubs 3.85855e-16
rt203_t0 t203__t0 t203 0.0275
rt203_t1 t203__t1 t203 0.0275
ct203 t203 vsubs 3.85855e-16
rt204_t0 t204__t0 t204 0.0275
rt204_t1 t204__t1 t204 0.0275
ct204 t204 vsubs 3.85855e-16
rt205_t0 t205__t0 t205 0.0275
rt205_t1 t205__t1 t205 0.0275
ct205 t205 vsubs 3.85855e-16
rt206_t0 t206__t0 t206 0.0275
rt206_t1 t206__t1 t206 0.0275
ct206 t206 vsubs 3.85855e-16
rt207_t0 t207__t0 t207 0.0275
rt207_t1 t207__t1 t207 0.0275
ct207 t207 vsubs 3.85855e-16
rt208_t0 t208__t0 t208 0.0275
rt208_t1 t208__t1 t208 0.0275
ct208 t208 vsubs 3.85855e-16
rt209_t0 t209__t0 t209 0.0275
rt209_t1 t209__t1 t209 0.0275
ct209 t209 vsubs 3.85855e-16
rt210_t0 t210__t0 t210 0.561
rt210_t1 t210__t1 t210 0.561
ct210 t210 vsubs 5.3264e-16
rt211_t0 t211__t0 t211 0.0275
rt211_t1 t211__t1 t211 0.0275
ct211 t211 vsubs 3.85855e-16
rt212_t0 t212__t0 t212 0.0275
rt212_t1 t212__t1 t212 0.0275
ct212 t212 vsubs 3.85855e-16
rt213_t0 t213__t0 t213 0.0275
rt213_t1 t213__t1 t213 0.0275
ct213 t213 vsubs 3.85855e-16
rt214_t0 t214__t0 t214 0.0275
rt214_t1 t214__t1 t214 0.0275
ct214 t214 vsubs 3.85855e-16
rt215_t0 t215__t0 t215 0.0275
rt215_t1 t215__t1 t215 0.0275
ct215 t215 vsubs 3.85855e-16
rt216_t0 t216__t0 t216 0.0275
rt216_t1 t216__t1 t216 0.0275
ct216 t216 vsubs 3.85855e-16
rt217_t0 t217__t0 t217 0.0275
rt217_t1 t217__t1 t217 0.0275
ct217 t217 vsubs 3.85855e-16
rt218_t0 t218__t0 t218 0.0275
rt218_t1 t218__t1 t218 0.0275
ct218 t218 vsubs 3.85855e-16
rt219_t0 t219__t0 t219 0.0275
rt219_t1 t219__t1 t219 0.0275
ct219 t219 vsubs 3.85855e-16
rt220_t0 t220__t0 t220 0.0275
rt220_t1 t220__t1 t220 0.0275
ct220 t220 vsubs 3.85855e-16
rt221_t0 t221__t0 t221 0.0275
rt221_t1 t221__t1 t221 0.0275
ct221 t221 vsubs 3.85855e-16
rt222_t0 t222__t0 t222 0.0275
rt222_t1 t222__t1 t222 0.0275
ct222 t222 vsubs 3.85855e-16
rt223_t0 t223__t0 t223 0.0275
rt223_t1 t223__t1 t223 0.0275
ct223 t223 vsubs 3.85855e-16
rt224_t0 t224__t0 t224 0.0275
rt224_t1 t224__t1 t224 0.0275
ct224 t224 vsubs 3.85855e-16
rt225_t0 t225__t0 t225 0.561
rt225_t1 t225__t1 t225 0.561
ct225 t225 vsubs 5.3264e-16
rt226_t0 t226__t0 t226 0.0275
rt226_t1 t226__t1 t226 0.0275
ct226 t226 vsubs 3.85855e-16
rt227_t0 t227__t0 t227 0.0275
rt227_t1 t227__t1 t227 0.0275
ct227 t227 vsubs 3.85855e-16
rt228_t0 t228__t0 t228 0.0275
rt228_t1 t228__t1 t228 0.0275
ct228 t228 vsubs 3.85855e-16
rt229_t0 t229__t0 t229 0.0275
rt229_t1 t229__t1 t229 0.0275
ct229 t229 vsubs 3.85855e-16
rt230_t0 t230__t0 t230 0.0275
rt230_t1 t230__t1 t230 0.0275
ct230 t230 vsubs 3.85855e-16
rt231_t0 t231__t0 t231 0.0275
rt231_t1 t231__t1 t231 0.0275
ct231 t231 vsubs 3.85855e-16
rt232_t0 t232__t0 t232 0.0275
rt232_t1 t232__t1 t232 0.0275
ct232 t232 vsubs 3.85855e-16
rt233_t0 t233__t0 t233 0.0275
rt233_t1 t233__t1 t233 0.0275
ct233 t233 vsubs 3.85855e-16
rt234_t0 t234__t0 t234 0.0275
rt234_t1 t234__t1 t234 0.0275
ct234 t234 vsubs 3.85855e-16
rt235_t0 t235__t0 t235 0.0275
rt235_t1 t235__t1 t235 0.0275
ct235 t235 vsubs 3.85855e-16
rt236_t0 t236__t0 t236 0.0275
rt236_t1 t236__t1 t236 0.0275
ct236 t236 vsubs 3.85855e-16
rt237_t0 t237__t0 t237 0.0275
rt237_t1 t237__t1 t237 0.0275
ct237 t237 vsubs 3.85855e-16
rt238_t0 t238__t0 t238 0.0275
rt238_t1 t238__t1 t238 0.0275
ct238 t238 vsubs 3.85855e-16
rt239_t0 t239__t0 t239 0.0275
rt239_t1 t239__t1 t239 0.0275
ct239 t239 vsubs 3.85855e-16
rt240_t0 t240__t0 t240 0.561
rt240_t1 t240__t1 t240 0.561
ct240 t240 vsubs 5.3264e-16
rt241_t0 t241__t0 t241 0.0275
rt241_t1 t241__t1 t241 0.0275
ct241 t241 vsubs 3.85855e-16
rt242_t0 t242__t0 t242 0.0275
rt242_t1 t242__t1 t242 0.0275
ct242 t242 vsubs 3.85855e-16
rt243_t0 t243__t0 t243 0.0275
rt243_t1 t243__t1 t243 0.0275
ct243 t243 vsubs 3.85855e-16
rt244_t0 t244__t0 t244 0.0275
rt244_t1 t244__t1 t244 0.0275
ct244 t244 vsubs 3.85855e-16
rt245_t0 t245__t0 t245 0.0275
rt245_t1 t245__t1 t245 0.0275
ct245 t245 vsubs 3.85855e-16
rt246_t0 t246__t0 t246 0.0275
rt246_t1 t246__t1 t246 0.0275
ct246 t246 vsubs 3.85855e-16
rt247_t0 t247__t0 t247 0.0275
rt247_t1 t247__t1 t247 0.0275
ct247 t247 vsubs 3.85855e-16
rt248_t0 t248__t0 t248 0.0275
rt248_t1 t248__t1 t248 0.0275
ct248 t248 vsubs 3.85855e-16
rt249_t0 t249__t0 t249 0.0275
rt249_t1 t249__t1 t249 0.0275
ct249 t249 vsubs 3.85855e-16
rt250_t0 t250__t0 t250 0.0275
rt250_t1 t250__t1 t250 0.0275
ct250 t250 vsubs 3.85855e-16
rt251_t0 t251__t0 t251 0.0275
rt251_t1 t251__t1 t251 0.0275
ct251 t251 vsubs 3.85855e-16
rt252_t0 t252__t0 t252 0.0275
rt252_t1 t252__t1 t252 0.0275
ct252 t252 vsubs 3.85855e-16
rt253_t0 t253__t0 t253 0.0275
rt253_t1 t253__t1 t253 0.0275
ct253 t253 vsubs 3.85855e-16
rt254_t0 t254__t0 t254 0.0275
rt254_t1 t254__t1 t254 0.0275
ct254 t254 vsubs 3.85855e-16
rtail_t0 tail__t0 tail 19.068
rtail_t1 tail__t1 tail 19.068
rtail_t2 tail__t2 tail 0.001
ctail tail vsubs 1.1326208e-14
rvdd_t0 vdd__t0 vdd 18.6125484662
rvdd_t1 vdd__t1 vdd 5.88221576652
rvdd_t2 vdd__t2 vdd 5.88221576652
rvdd_t3 vdd__t3 vdd 28.5901117754
rvdd_t4 vdd__t4 vdd 9.3897091172
rvdd_t5 vdd__t5 vdd 9.3897091172
rvdd_t6 vdd__t6 vdd 7.205531538
rvdd_t7 vdd__t7 vdd 7.205531538
rvdd_t8 vdd__t8 vdd 5.40357674796
rvdd_t9 vdd__t9 vdd 5.40357674796
rvdd_t10 vdd__t10 vdd 9.62283858919
rvdd_t11 vdd__t11 vdd 7.42676376421
rvdd_t12 vdd__t12 vdd 9.62283858919
rvdd_t13 vdd__t13 vdd 7.42676376421
rvdd_t14 vdd__t14 vdd 11.6482313507
rvdd_t15 vdd__t15 vdd 7.01806970924
rvdd_t16 vdd__t16 vdd 18.0657770283
rvdd_t17 vdd__t17 vdd 11.6482313507
rvdd_t18 vdd__t18 vdd 7.01806970924
rvdd_t19 vdd__t19 vdd 18.0657770283
rvdd_t20 vdd__t20 vdd 11.2567125357
cvdd vdd vsubs 5.5970539e-14
rvref_t0 vref__t0 vref 5.22771494039
rvref_t1 vref__t1 vref 7.94398451228
rvref_t2 vref__t2 vref 8.32710570991
rvref_t3 vref__t3 vref 2.64799483743
cvref vref vsubs 7.999253e-15
rvss_t0 vss__t0 vss 4.58349585976
rvss_t1 vss__t1 vss 1.42011294368
rvss_t2 vss__t2 vss 1.86193069608
rvss_t3 vss__t3 vss 3.71821640245
rvss_t4 vss__t4 vss 2.33719860398
rvss_t5 vss__t5 vss 2.18609336443
rvss_t261 vss__t261 vss 2.83766917226
rvss_t262 vss__t262 vss 1.30352481806
rvss_t263 vss__t263 vss 1.75252163982
rvss_t264 vss__t264 vss 4.58349585976
rvss_t265 vss__t265 vss 3.71821640245
rvss_t266 vss__t266 vss 2.18609336443
rvss_t267 vss__t267 vss 2.33719860398
rvss_t268 vss__t268 vss 1.42011294368
rvss_t269 vss__t269 vss 1.86193069608
cvss vss vsubs 5.9622954e-14
ccc_cb2_vdd cb2 vdd 8.235e-18
ccc_cb2_vss cb2 vss 3.0251e-17
ccc_cb3_tn0 cb3 tn0 1.1764e-17
ccc_cb3_vdd cb3 vdd 8.235e-18
ccc_cb3_vref cb3 vref 8.235e-18
ccc_cb3_vss cb3 vss 2.0167e-17
ccc_d1_d2 d1 d2 1.4117e-17
ccc_d1_vss d1 vss 3.3411e-17
ccc_d2_fb d2 fb 1.4117e-17
ccc_det_vdd det vdd 8.235e-18
ccc_fb_sns1 fb sns1 2.1176e-17
ccc_fb_pn fb pn 1.4117e-17
ccc_fb_vdd fb vdd 3.3485e-17
ccc_fb_vss fb vss 4.0543e-17
ccc_sns1_sns2 sns1 sns2 1.4117e-17
ccc_sns1_tail sns1 tail 7.059e-18
ccc_sns1_vdd sns1 vdd 2.523e-17
ccc_sns1_vss sns1 vss 4.4368e-17
ccc_sns2_vdd sns2 vdd 2.2352e-17
ccc_tn0_t002 tn0 t002 8.067e-17
ccc_tn0_t004 tn0 t004 8.067e-17
ccc_tn0_t005 tn0 t005 8.067e-17
ccc_tn0_t006 tn0 t006 8.067e-17
ccc_tn0_t008 tn0 t008 8.067e-17
ccc_tn0_t009 tn0 t009 8.067e-17
ccc_tn0_t010 tn0 t010 8.067e-17
ccc_tn0_t011 tn0 t011 8.067e-17
ccc_tn0_t012 tn0 t012 8.067e-17
ccc_tn0_t013 tn0 t013 8.067e-17
ccc_tn0_t014 tn0 t014 8.067e-17
ccc_tn0_t032 tn0 t032 8.067e-17
ccc_tn0_t033 tn0 t033 8.067e-17
ccc_tn0_t034 tn0 t034 8.067e-17
ccc_tn0_t035 tn0 t035 8.067e-17
ccc_tn0_t036 tn0 t036 8.067e-17
ccc_tn0_t037 tn0 t037 8.067e-17
ccc_tn0_t038 tn0 t038 8.067e-17
ccc_tn0_t039 tn0 t039 8.067e-17
ccc_tn0_t040 tn0 t040 8.067e-17
ccc_tn0_t041 tn0 t041 8.067e-17
ccc_tn0_t042 tn0 t042 8.067e-17
ccc_tn0_t043 tn0 t043 8.067e-17
ccc_tn0_t044 tn0 t044 8.067e-17
ccc_tn0_t045 tn0 t045 4.8738e-17
ccc_tn0_t059 tn0 t059 1.21005e-16
ccc_tn0_t061 tn0 t061 1.0756e-16
ccc_tn0_t062 tn0 t062 8.067e-17
ccc_tn0_t087 tn0 t087 1.21005e-16
ccc_tn0_t093 tn0 t093 1.21005e-16
ccc_tn0_t117 tn0 t117 1.21005e-16
ccc_tn0_t123 tn0 t123 1.0756e-16
ccc_tn0_t124 tn0 t124 8.067e-17
ccc_tn0_t125 tn0 t125 8.067e-17
ccc_tn0_t126 tn0 t126 8.067e-17
ccc_tn0_vref tn0 vref 1.1764e-17
ccc_tail_vdd tail vdd 2.7367e-17
ccc_tail_vss tail vss 8.235e-18
ccc_vdd_vref vdd vref 1.4117e-17
ccc_vdd_vss vdd vss 2.3381e-17
rvsubs_dctie vsubs 0 1e+12
* --- end pex_body.inc ---

* Batch mode only (issue #278 per-process bridge): the two families the
* request's single models.lib (klt 0.5.0 on the runner) cannot reach, as
* selection-form `.lib` cards against the image's baked PDK root. Same
* CORNER_SECTIONS entry the request's models.lib selects the HBT family
* from. Corner: sf; supply: 2.97 V.
.lib "${PDK_ROOT}/ihp-sg13g2/libs.tech/ngspice/models/cornerMOShv.lib" mos_sf
.lib "${PDK_ROOT}/ihp-sg13g2/libs.tech/ngspice/models/cornerRES.lib" res_typ
* --- end body-fixed-sf-2p97.spice ---
.temp 125
.meas ac zout_dc_lin find vm(vref) at=1
.meas ac zout_1khz_lin find vm(vref) at=1k
.meas ac zout_100khz_lin find vm(vref) at=100k
.meas ac zout_1mhz_lin find vm(vref) at=1meg
.control
ac dec 30 1 1e9
quit
.endc
.end
