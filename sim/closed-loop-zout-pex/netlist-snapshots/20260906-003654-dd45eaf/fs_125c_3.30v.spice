* sg13g2-bandgap -- closed-loop AC output-impedance-at-vref PEX (post-layout)
* PVT testbench (issue #191, independent confirmation of the
* closed-loop-psrr-pex ~30 MHz PSRR dip). Generated from
* sim/closed-loop-zout-pex/testbench/tb_closed_loop_zout_pex.spice.tmpl by
* sim/closed-loop-zout-pex/run_pvt_sweep.sh -- do not edit a generated
* netlist-snapshots/*.spice file directly, edit this template and re-run the
* sweep. Full rationale is in sim/closed-loop-zout-pex/README.md; this header
* is a pointer, not a restatement.
*
* Generated for: corner=fs temp=125C vdd=3.30V
* DUT git sha (design/netlist/bandgap_core.spice, for XQ1/XQ2/XQ3, the
* only devices this bench still splices from a schematic):
*   core=d83f7c4 amp=397fe2d startup=66ac99d seeds=20260830-132425-d83f7c4.csv@94207b4
* Layout git sha (layout/bandgap_top/bandgap_top.pex.spice, extraction
* input for every MOS/resistor device and every wire parasitic):
*   8abe2aa
* PDK: ihp-sg13g2 /home/ubuntu/share/pdk (see sim/pdk.json for the pinned release)
* OSDI models: /home/ubuntu/share/pdk/ihp-sg13g2/libs.tech/ngspice/osdi (built by sim/tools/build-osdi.sh)
*
* WHY THIS BENCH EXISTS -- issue #191 asks for an independent confirmation,
* distinct from sim/closed-loop-psrr-pex's own supply-injection measurement,
* of whether that experiment's 27.1-31.6 MHz worst-case-PSRR dip
* (records/20260905-233826-f6f3efc.csv) is the closed loop's OWN resonance
* interacting with the extracted wire parasitics, or an artifact of
* injecting the stimulus on vdd specifically (upstream of the extracted
* supply-wire resistance/capacitance). This bench answers that by measuring
* a DIFFERENT closed-loop transfer function that shares the same
* "1/(1+T(s))" return-difference denominator PSRR does, but is stimulated
* at a completely different port: instead of a 1V/0deg AC perturbation on
* vdd with the output read at vref (PSRR), this bench injects a 1A/0deg AC
* TEST CURRENT directly at vref (vdd is now a plain DC source, unperturbed)
* and reads the resulting v(vref) -- i.e. the closed-loop small-signal
* output impedance Zout(f) = v(vref)/i(Itest) looking into vref. Both PSRR
* and Zout degrade (peak/notch) together exactly where the loop's own
* return difference 1+T(jw) gets small -- that is a property of the loop
* itself, not of which port happens to be stimulated. If Zout ALSO peaks
* near 27-31 MHz on this same extracted netlist, that is evidence the
* mechanism is the loop's own resonance (present regardless of injection
* port); if Zout stays flat/monotonic through that band while PSRR still
* dips there, that would instead point at something specific to the vdd
* injection path (e.g. the extracted vdd wire network's own resonance).
* See README.md "Why an output-impedance probe" for the full argument.
*
* THIS IS THE DEVICE/PARASITIC HALF verbatim of
* sim/closed-loop-psrr-pex/testbench/tb_closed_loop_psrr_pex.spice.tmpl
* (itself the device/parasitic half of
* sim/closed-loop-vref-pvt-pex/testbench/tb_closed_loop_vref_pex.spice.tmpl,
* same extraction, same instance names, same wire-parasitic block) -- every
* device card and every wire-parasitic line below is byte-for-byte identical
* to that file; only the injection/measurement FIXTURE and the .control
* block differ. This bench does NOT break the loop anywhere (unlike
* sim/loop-gain-phase-margin's Middlebrook probe) -- fb remains one single
* node exactly as bandgap_top.sch wires it and exactly as the extraction's
* own single "fb" hub node models it. Everything
* sim/closed-loop-vref-pvt-pex/README.md documents about what the extraction
* does and does not model (bipolar devices spliced in, D/S terminal roles
* possibly swapped, body/well ties real, the three merged-net labels) and
* everything sim/closed-loop-psrr-pex/README.md documents about the vsubs
* tie choice applies here unchanged and is not restated.
*
* DELTA vs. tb_closed_loop_psrr_pex.spice.tmpl -- exactly two:
*   1. Vvdd carries ONLY the fixed DC operating point here (no AC term) --
*      vdd is not the stimulus in this bench.
*   2. Itest is a new 1A/0deg AC current source injected directly at vref
*      (DC = 0, so it does not perturb the .nodeset-seeded DC operating
*      point at all); v(vref) is read directly as the complex impedance
*      Zout(f), since a 1A magnitude stimulus makes v(vref) numerically
*      equal to Zout in ohms.
.nodeset v(fb)=2.52724e+00 v(sns1)=5.90124e-01 v(sns2)=5.89840e-01 v(vref)=1.04761e+00

.lib "/home/ubuntu/share/pdk/ihp-sg13g2/libs.tech/ngspice/models/cornerHBT.lib" hbt_typ
.lib "/home/ubuntu/share/pdk/ihp-sg13g2/libs.tech/ngspice/models/cornerMOShv.lib" mos_fs
.lib "/home/ubuntu/share/pdk/ihp-sg13g2/libs.tech/ngspice/models/cornerRES.lib" res_typ

.options temp=125 tnom=27

* FIXTURE -- vdd is a FIXED DC source here (DELTA 1 above): this bench's
* stimulus is Itest at vref, not vdd. Vvss is a separate, unperturbed 0V
* source, same as every other closed-loop bench in this tree.
Vvdd vdd 0 dc 3.30
Vvss vss 0 dc 0

* FIXTURE -- substrate/far-plate return for every extracted ground
* capacitance below, shorted to vss -- same choice and same rationale as
* sim/closed-loop-psrr-pex (see that experiment's README "The vsubs tie
* matters here"): a frequency-domain bench cannot use the transient/DC PEX
* benches' 1 TOhm DC-only tie, because at AC that would leave vsubs
* effectively floating and turn every net's ground cap into a net-to-net
* coupling cap instead of a cap to ground. A 0V source is a DC and AC short
* and injects nothing of its own.
Vvsubs vsubs vss dc 0

* STIMULUS -- Itest injects a 1A/0deg AC test current directly into the
* vref node (DC = 0, so the .nodeset-seeded DC operating point above is
* undisturbed). "0 vref" ordering: SPICE convention is that current flows
* from N+ to N- THROUGH the source, so externally it is delivered TO N-
* (vref) FROM N+ (here node 0) -- i.e. this pushes 1A of test current INTO
* vref from outside the loop, exactly the classic single-current-injection
* output-impedance probe. Because the loop is fully closed here (unlike
* sim/loop-gain-phase-margin's broken-loop Vtest), v(vref)/i(Itest) is the
* CLOSED-LOOP output impedance Zout(f), not an open-loop quantity.
Itest 0 vref dc 0 ac 1 0

* DUT -- bandgap_core devices, extracted from layout/bandgap_top/
* bandgap_top.pex.spice (M$12-M$17, R$18/R$19) except XQ1-XQ3 (spliced,
* see file header). Each MOS/resistor keeps its extracted per-terminal
* wire-parasitic hub node; ng=1/m=1/b=0 restored on each so this bench's
* per-point netlist snapshot compares equal to design/netlist/
* bandgap_core.spice's own device signature (extra as/ad/ps/pd tolerated,
* see check_evidence_formats.py's dut_signature() docstring).
XM1 vdd__t14 fb__t6 sns1__t2 vdd__t11 sg13_hv_pmos w=10u l=1u ng=1 m=1 as=4p ad=4p ps=20.8u pd=20.8u
XQ1 sns1 sns1 vss vss npn13G2 Nx=1
XM2A vdd__t7 fb__t5 sns2__t0 vdd__t8 sg13_hv_pmos w=9u l=1u ng=1 m=1 as=3.6p ad=3.6p ps=18.8u pd=18.8u
XM2B vdd__t20 fb__t8 sns2__t1 vdd__t18 sg13_hv_pmos w=1u l=1u ng=1 m=1 as=0.4p ad=0.4p ps=2.8u pd=2.8u
XR2 sns2__t2 cb2__t0 vss__t6 rppd w=2u l=82.7u m=1 b=0
XQ2 cb2 cb2 vss vss npn13G2 Nx=8
XM3A vdd__t5 fb__t3 vref__t1 vdd__t6 sg13_hv_pmos w=8u l=1u ng=1 m=1 as=3.2p ad=3.2p ps=16.8u pd=16.8u
XM3B vdd__t1 fb__t7 vref__t3 vdd__t2 sg13_hv_pmos w=1u l=1u ng=1 m=1 as=0.4p ad=0.4p ps=2.8u pd=2.8u
XM3C vdd__t19 fb__t2 vref__t2 vdd__t17 sg13_hv_pmos w=1u l=1u ng=1 m=1 as=0.4p ad=0.4p ps=2.8u pd=2.8u
XR1 vref__t0 cb3__t0 vss__t7 rppd w=2u l=511u m=1 b=0
XQ3 cb3 cb3 vss vss npn13G2 Nx=1

* DUT -- bandgap_amp devices, extracted (M$1-M$4, M$7-M$11). D/S terminal
* roles read from the extraction as-is (nd/ng/ns/nb card order); harmless
* where swapped relative to the schematic's own d/g/s/b convention, same
* "symmetric AS=AD, PS=PD" argument sim/core-open-loop-bias-pex's header
* makes for the core mirror legs.
XMN1 d1__t1 d1__t3 vss__t5 vss__t9 sg13_hv_nmos w=10u l=1u ng=1 m=1 as=4p ad=4p ps=20.8u pd=20.8u
XMN2 d2__t1 d2__t3 vss__t4 vss__t10 sg13_hv_nmos w=10u l=1u ng=1 m=1 as=4p ad=4p ps=20.8u pd=20.8u
XMN3 fb__t9 d1__t0 vss__t0 vss__t11 sg13_hv_nmos w=10u l=1u ng=1 m=1 as=4p ad=4p ps=20.8u pd=20.8u
XMN4 pn__t3 d2__t2 vss__t3 vss__t12 sg13_hv_nmos w=10u l=1u ng=1 m=1 as=4p ad=4p ps=20.8u pd=20.8u
XMP1 tail__t0 sns2__t3 d1__t2 vdd__t10 sg13_hv_pmos w=20u l=1u ng=1 m=1 as=8p ad=8p ps=40.8u pd=40.8u
XMP2 tail__t1 sns1__t1 d2__t0 vdd__t9 sg13_hv_pmos w=20u l=1u ng=1 m=1 as=8p ad=8p ps=40.8u pd=40.8u
XMP3 vdd__t15 pn__t1 pn__t2 vdd__t12 sg13_hv_pmos w=10u l=1u ng=1 m=1 as=4p ad=4p ps=20.8u pd=20.8u
XMP4 vdd__t3 pn__t0 fb__t0 vdd__t4 sg13_hv_pmos w=10u l=1u ng=1 m=1 as=4p ad=4p ps=20.8u pd=20.8u
XMTAIL vdd__t16 fb__t4 tail__t2 vdd__t13 sg13_hv_pmos w=10u l=1u ng=1 m=1 as=4p ad=4p ps=20.8u pd=20.8u

* DUT -- bandgap_startup devices, extracted (M$5, R$20), except XMKFB's
* drain (see below). `sns1`/`fb` are the same shared merged-label nets the
* core/amp devices above already use.
XRPU vdd__t0 det__t2 vss__t8 rhigh w=1u l=1411.3u m=1 b=0
XMSENSE det__t0 sns1__t0 vss__t1 vss__t13 sg13_hv_nmos w=10u l=0.5u ng=1 m=1 as=4p ad=4p ps=20.8u pd=20.8u
* FIXTURE -- Vmkfb is a 0V ammeter in series with XMKFB's own drain
* terminal and its extracted fb__t1 wire-parasitic hub leg (see
* sim/closed-loop-psrr-pex/testbench's own header for the terminal-order/
* sign-parity rationale, not repeated here -- this bench does not measure
* i(Vmkfb) either, same as that one).
XMKFB i_mkfb_probe det__t1 vss__t2 vss__t14 sg13_hv_nmos w=2u l=0.5u ng=1 m=1 as=0.8p ad=0.8p ps=4.8u pd=4.8u
Vmkfb fb__t1 i_mkfb_probe dc 0

* Wire parasitics -- verbatim from layout/bandgap_top/bandgap_top.pex.spice
* (issue #186), after the FB|OUT/IN_N|SNS1/IN_P|SNS2 -> fb/sns1/sns2 net
* renames the file header documents.
* sim/tools/dump_pex_wire_parasitics.py --wires-only
* layout/bandgap_top/bandgap_top.pex.spice emits this block mechanically
* (still requires the fb/sns1/sns2 rename by hand).
rcb2_t0 cb2__t0 cb2 23.2474
ccb2 cb2 vsubs 7.410176e-15
rcb3_t0 cb3__t0 cb3 16.8479
ccb3 cb3 vsubs 5.212856e-15
rd1_t0 d1__t0 d1 22.251200155
rd1_t1 d1__t1 d1 7.56616839856
rd1_t2 d1__t2 d1 8.79506304785
rd1_t3 d1__t3 d1 7.56616839856
cd1 d1 vsubs 1.6632756e-14
rd2_t0 d2__t0 d2 9.68094774475
rd2_t1 d2__t1 d2 8.5847146177
rd2_t2 d2__t2 d2 25.3624230198
rd2_t3 d2__t3 d2 8.5847146177
cd2 d2 vsubs 1.8465821e-14
rdet_t0 det__t0 det 7.2824560321
rdet_t1 det__t1 det 4.66093626702
rdet_t2 det__t2 det 8.58380770088
cdet det vsubs 5.249053e-15
rfb_t0 fb__t0 fb 10.0779438037
rfb_t1 fb__t1 fb 16.9232599379
rfb_t2 fb__t2 fb 8.13495243784
rfb_t3 fb__t3 fb 4.44930412939
rfb_t4 fb__t4 fb 7.15861618793
rfb_t5 fb__t5 fb 12.5640343804
rfb_t6 fb__t6 fb 21.8872074761
rfb_t7 fb__t7 fb 6.03518929088
rfb_t8 fb__t8 fb 10.1675460999
rfb_t9 fb__t9 fb 14.6461462559
cfb fb vsubs 3.208914e-14
rsns1_t0 sns1__t0 sns1 45.1997691206
rsns1_t1 sns1__t1 sns1 16.9490366062
rsns1_t2 sns1__t2 sns1 34.0487942731
csns1 sns1 vsubs 2.4554821e-14
rsns2_t0 sns2__t0 sns2 4.15668326281
rsns2_t1 sns2__t1 sns2 8.64200634581
rsns2_t2 sns2__t2 sns2 11.7618532043
rsns2_t3 sns2__t3 sns2 22.8884571871
csns2 sns2 vsubs 1.3888551e-14
rpn_t0 pn__t0 pn 1.86815055391
rpn_t1 pn__t1 pn 7.70258205833
rpn_t2 pn__t2 pn 7.70258205833
rpn_t3 pn__t3 pn 15.9614853294
cpn pn vsubs 1.131071e-14
rtail_t0 tail__t0 tail 19.17885
rtail_t1 tail__t1 tail 0.001
rtail_t2 tail__t2 tail 19.17885
ctail tail vsubs 1.1326208e-14
rvdd_t0 vdd__t0 vdd 18.537690531
rvdd_t1 vdd__t1 vdd 7.40498257743
rvdd_t2 vdd__t2 vdd 7.40498257743
rvdd_t3 vdd__t3 vdd 11.3874080082
rvdd_t4 vdd__t4 vdd 11.3874080082
rvdd_t5 vdd__t5 vdd 5.44971952132
rvdd_t6 vdd__t6 vdd 5.44971952132
rvdd_t7 vdd__t7 vdd 8.4721636541
rvdd_t8 vdd__t8 vdd 8.4721636541
rvdd_t9 vdd__t9 vdd 10.2657906969
rvdd_t10 vdd__t10 vdd 17.1779353262
rvdd_t11 vdd__t11 vdd 16.6484966651
rvdd_t12 vdd__t12 vdd 6.89988867478
rvdd_t13 vdd__t13 vdd 5.4442468209
rvdd_t14 vdd__t14 vdd 16.6484966651
rvdd_t15 vdd__t15 vdd 6.89988867478
rvdd_t16 vdd__t16 vdd 5.4442468209
rvdd_t17 vdd__t17 vdd 9.49860222484
rvdd_t18 vdd__t18 vdd 6.43133357626
rvdd_t19 vdd__t19 vdd 9.49860222484
rvdd_t20 vdd__t20 vdd 6.43133357626
cvdd vdd vsubs 5.1666163e-14
rvref_t0 vref__t0 vref 9.41352863345
rvref_t1 vref__t1 vref 5.78599551376
rvref_t2 vref__t2 vref 6.02653297497
rvref_t3 vref__t3 vref 3.13784287782
cvref vref vsubs 8.002435e-15
rvss_t0 vss__t0 vss 5.37858226607
rvss_t1 vss__t1 vss 6.31278904894
rvss_t2 vss__t2 vss 8.89142058204
rvss_t3 vss__t3 vss 12.1056726523
rvss_t4 vss__t4 vss 11.9685952562
rvss_t5 vss__t5 vss 17.2509843632
rvss_t6 vss__t6 vss 12.9820270411
rvss_t7 vss__t7 vss 10.0779208618
rvss_t8 vss__t8 vss 10.9495637595
rvss_t9 vss__t9 vss 17.2509843632
rvss_t10 vss__t10 vss 11.9685952562
rvss_t11 vss__t11 vss 5.37858226607
rvss_t12 vss__t12 vss 12.1056726523
rvss_t13 vss__t13 vss 6.31278904894
rvss_t14 vss__t14 vss 8.89142058204
cvss vss vsubs 5.5318578e-14
ccc_cb2_vdd cb2 vdd 8.235e-18
ccc_cb2_vss cb2 vss 3.0251e-17
ccc_cb3_vdd cb3 vdd 8.235e-18
ccc_cb3_vref cb3 vref 8.235e-18
ccc_cb3_vss cb3 vss 2.0167e-17
ccc_d1_d2 d1 d2 1.4117e-17
ccc_d1_vss d1 vss 3.3411e-17
ccc_d2_fb d2 fb 1.4117e-17
ccc_det_vdd det vdd 8.235e-18
ccc_fb_sns1 fb sns1 2.1176e-17
ccc_fb_pn fb pn 1.4117e-17
ccc_fb_vdd fb vdd 3.3485e-17
ccc_fb_vss fb vss 4.0543e-17
ccc_sns1_sns2 sns1 sns2 1.4117e-17
ccc_sns1_tail sns1 tail 7.059e-18
ccc_sns1_vdd sns1 vdd 2.523e-17
ccc_sns1_vss sns1 vss 4.4368e-17
ccc_sns2_vdd sns2 vdd 2.2352e-17
ccc_tail_vdd tail vdd 2.7367e-17
ccc_tail_vss tail vss 8.235e-18
ccc_vdd_vref vdd vref 1.4117e-17
ccc_vdd_vss vdd vss 2.3381e-17

.control
pre_osdi /home/ubuntu/share/pdk/ihp-sg13g2/libs.tech/ngspice/osdi/psp103.osdi
pre_osdi /home/ubuntu/share/pdk/ihp-sg13g2/libs.tech/ngspice/osdi/psp103_nqs.osdi
pre_osdi /home/ubuntu/share/pdk/ihp-sg13g2/libs.tech/ngspice/osdi/mosvar.osdi
pre_osdi /home/ubuntu/share/pdk/ihp-sg13g2/libs.tech/ngspice/osdi/r3_cmc.osdi
op
* Sanity check, same as sim/closed-loop-psrr-pex: if .op strayed into the
* wrong equilibrium, fb here will read far from 2.52724e+00. ngspice has no
* ".meas op" analysis type; "print" is this tree's standard way to pull a DC
* operating-point value out of a .control block, parsed by run_pvt_sweep.sh
* from this exact "v(node) = value" line shape.
print v(fb)
print v(sns1)
print v(sns2)
print v(vref)
ac dec 30 1 1e9
* zout_db/zout_phase_deg: v(vref) IS Zout(f) in ohms (real+imag), since
* Itest's AC magnitude is exactly 1A -- db(v(vref)) is therefore
* 20*log10(|Zout|/1 ohm), not a rejection ratio.
let zout_db = db(v(vref))
let zout_phase_deg = cph(v(vref))*180/PI
wrdata /home/ubuntu/GitHub/sg13g2-bandgap/.loom/worktrees/issue-191/sim/closed-loop-zout-pex/corners/20260906-003654-dd45eaf/fs_125c_3.30v.ac.txt zout_db zout_phase_deg
.endc
.end
