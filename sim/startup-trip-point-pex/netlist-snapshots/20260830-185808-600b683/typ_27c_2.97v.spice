* sg13g2-bandgap -- bandgap_startup PEX (post-layout) PVT testbench
* (issue #14). Generated from
* sim/startup-trip-point-pex/testbench/tb_startup_trip_point_pex.spice.tmpl
* by sim/startup-trip-point-pex/run_pvt_sweep.sh -- do not edit a generated
* netlist-snapshots/*.spice file directly, edit this template and re-run
* the sweep. Full rationale is in sim/startup-trip-point-pex/README.md.
*
* Generated for: corner=typ temp=27C vdd=2.97V
* DUT git sha (design/netlist/bandgap_startup.spice -- as of issue #59,
* nothing in this testbench is spliced in verbatim from that file anymore
* (XMSENSE/XMKFB since issue #14/#32, XRPU's resistor since issue #59, are
* all re-encoded from the layout extraction); still recorded for
* traceability against the schematic's own nominal geometry -- see below):
*   66ac99d
* Layout git sha (layout/bandgap_startup/bandgap_startup.gds, extraction
* input):
*   600b683
* PDK: ihp-sg13g2 /home/ubuntu/share/pdk (see sim/pdk.json for the pinned release)
* OSDI models: /home/ubuntu/share/pdk/ihp-sg13g2/libs.tech/ngspice/osdi (built by sim/tools/build-osdi.sh)
*
* THIS IS A HYBRID PEX NETLIST, NOT A PURE LAYOUT EXTRACTION -- read
* sim/startup-trip-point-pex/README.md "What this does and does not
* model" before trusting a result here. Short version:
*   - XMSENSE/XMKFB (both sg13_hv_nmos) are re-encoded from `klt extract
*     --deck sg13g2 --parasitics layout/bandgap_startup/
*     bandgap_startup.gds` (layout/bandgap_startup/bandgap_startup.pex.spice,
*     pex_extract_report.json): real drawn W/L and junction AS/AD/PS/PD
*     from the routed layout, re-expressed as X-subckt calls to the real
*     sg13_hv_nmos compact model. Their D/G/S node roles match the
*     schematic's own convention exactly (no swap, unlike
*     core-open-loop-bias-pex) -- only the body terminal differs (see
*     below).
*   - **XMSENSE's extracted width is now w=10u, matching the schematic
*     (issue #32).** The committed layout
*     (layout/bandgap_startup/generate.py, issue #11/PR #19) originally
*     drew XMSENSE at w=2u, before decision record 0003 (issue #24/PR #29)
*     widened it to w=10u in design/netlist/bandgap_startup.spice to fix a
*     real 125C startup-release margin bug -- the layout was not
*     regenerated to match until issue #32. This testbench is
*     as-drawn (w=10u): PEX evidence now reflects the corrected, in-sync
*     layout. See sim/startup-trip-point-pex/README.md for the full
*     before/after account.
*   - This direct sns1-sweep methodology (0 -> vdd) does NOT, by itself,
*     reveal decision record 0003's original margin bug either way (at
*     w=2u or w=10u) -- it always reaches full release by the time sns1
*     hits vdd, same limitation sim/startup-trip-point's own (pre-PEX)
*     records already note. Whether the margin bug is present only shows
*     up by comparing this record's `vtrip_v` against
*     sim/core-open-loop-bias-pex's own real `sns1` operating point at the
*     same corner -- see sim/startup-trip-point-pex/README.md
*     "Cross-bench observation" for that comparison, which at the
*     corrected w=10u width now clears at all 45 points (the 4 points that
*     failed at the stale w=2u width -- wcs_125c_{2.97,3.30,3.63}v,
*     sf_125c_3.63v -- now pass).
*   - XRPU (rhigh) is now instantiated from the extracted R$3 device
*     (issue #59) instead of being spliced verbatim from
*     design/netlist/bandgap_startup.spice -- PR #45's resistor marker
*     layers made the sg13g2 deck's `rhigh` recognizer actually match this
*     layout's poly resistor (pex_extract_report.json's device_counts reads
*     `{"nfet": 2, "rhigh": 1}`). IMPORTANT caveat, confirmed by direct
*     ngspice testing, not assumed from bandgap_startup.pex.spice's own
*     text: that file's native `R$3 \$5__t0 det__t0 vsubs 1919368 rhigh`
*     card is NOT literal simulatable ngspice syntax (a 2-terminal `R`
*     element cannot take a 3rd node before its value -- ngspice errors
*     "unknown parameter (vsubs)") -- `rhigh`/`rppd` are PDK subckts
*     (`1 2 bn` pins), the same situation the nfet M-cards above already
*     needed X-subckt re-encoding for. XRPU below is therefore an X-subckt
*     call to the real `rhigh` subckt using pex_extract_report.json's own
*     drawn `w_um`/`l_um` (numerically identical to the schematic's own
*     nominal `w`/`l` -- this is a fixed-geometry poly resistor, so this
*     pass buys no *geometry* correction, only the bulk-node correction
*     below, the isolated \$5 net's termination, and the newly-wired
*     hub-terminal parasitics). R$3's own "a" terminal lands on an
*     isolated, unlabeled two-node net (`\$5`/`\$5__t0`) rather than the
*     schematic's real `vdd` -- this layout simply never exposes `vdd` as a
*     declared pin at all (`.SUBCKT bandgap_startup det fb vss vsubs`, no
*     `vdd`), a layout-labeling gap distinct from the marker-layer gap PR
*     #45 fixed, out of this issue's own scope. FIXTURE 3 below ties `\$5`
*     to `vdd` directly (a 0 V source, so `i(vtie5)` reads R$3's own
*     current), the testbench's own resolution for that gap -- not a claim
*     that the real layout routes `\$5` to `vdd`. Bulk lands on `vsubs`
*     (the extraction's real reported bulk net), not the schematic's
*     `sub!` -- the now-unused `Vsub sub! vss` fixture is removed below.
*     Separately: `pex_extract_report.json`'s own `r_ohm` field (1919368)
*     is klt's own first-order `rsh * l_um / w_um` sheet-resistance
*     estimate (confirmed exactly: `1360 * 1411.3 / 1 = 1919368`), not the
*     full `r3_cmc` compact-model resistance -- simulating the X-subckt
*     form above at the same drawn geometry computes ~2.086 Mohm (res_typ,
*     27C), ~8.7% above `r_ohm` (larger than the two rppd resistors'
*     ~0.5% gap in core-open-loop-bias-pex -- the compact model's
*     contact/end-effect terms scale differently for this much
*     narrower/longer device). Disclosed, not silently reconciled.
*   - Both extracted devices' body terminals land on the deck's own
*     synthesized global fallback net (`vsubs` in
*     layout/bandgap_startup/bandgap_startup.pex.spice), not the
*     schematic's real body-tied-to-vss (klayout-tools, filed generically;
*     see layout/README.md's LVS cause 2). This testbench ties body to
*     vss directly, mirroring the schematic's real intent, rather than
*     wiring to a deck-synthesized net this testbench has no independent
*     way to validate.
*   - klayout-tools#1280/#1282 (issue #37) populated the sg13g2 deck's
*     PARASITICS.metals/metal_overlaps coefficient tables (Metal1/Metal2,
*     later the full Metal1-TopMetal2 stack). Re-extracting against the
*     current deck now yields non-zero r_count/c_count -- this run wires
*     in those wire R/C cards verbatim (see "Wire parasitics" below), the
*     first PEX record here to carry them. XMSENSE's gate net \$4 gets no
*     wire model either way (a single-terminal, deck-disconnected net in
*     this isolated cell's own extraction -- the testbench's own `sns1`
*     drive below is a fixture bridging that gap, unchanged by this pass).

.lib "/home/ubuntu/share/pdk/ihp-sg13g2/libs.tech/ngspice/models/cornerMOShv.lib" mos_tt
.lib "/home/ubuntu/share/pdk/ihp-sg13g2/libs.tech/ngspice/models/cornerRES.lib" res_typ

.options temp=27 tnom=27

Vvdd vdd 0 dc 2.97
Vvss vss 0 dc 0
* bandgap_startup.spice's schematic-splice convention wired the rhigh bulk
* terminal to the global substrate net `sub!`, fixtured to vss via a 0 V
* source (sim/startup-trip-point's own fixture). As of issue #59, XRPU
* below is the extracted R$3 device instead, whose real bulk net is
* `vsubs` -- already stabilized by `Rvsubs_dctie` in the "Wire parasitics"
* block below -- so the `sub!`/`Vsub` fixture is no longer referenced by
* anything in this file and is removed rather than left as dead code.

* FIXTURE 1 -- sns1 stimulus, same convention as sim/startup-trip-point:
* sns1 is bandgap_core's own sense node in the assembled block; here it is
* driven directly so the startup circuit's response can be swept from
* "core is dead" (sns1 = 0) to "core is up" (sns1 = vdd) in one analysis.
Vsns1 sns1 vss dc 0

* FIXTURE 2 -- fb load, same convention as sim/startup-trip-point: nothing
* drives fb high in the design yet (no error amplifier -- issue #9's scope
* cut), so this weak pull-up stands in for whatever eventually holds fb
* high once XMKFB turns off.
Rfbpu vdd fb 10meg

* FIXTURE 3 -- isolated $5 net termination. See file header above for why
* R$3's own "a" terminal lands on this isolated, unlabeled net rather than
* a real `vdd` pin; this 0 V source ties it to `vdd` directly (a real
* short, not a high-impedance approximation), so `i(vtie5)` also reads
* R$3's own device current.
Vtie5 \$5 vdd dc 0

* Resistor -- extracted from the routed layout as of issue #59 (R$3 in
* layout/bandgap_startup/bandgap_startup.pex.spice), re-encoded as an
* X-subckt call to the real rhigh PDK subckt (see file header for why the
* pex.spice file's own native R$3 card is not directly simulatable, and
* for the r_ohm-vs-simulated-resistance caveat). XRPU keeps the
* schematic's own instance name for continuity.
XRPU \$5__t0 det__t0 vsubs rhigh w=1u l=1411.3u m=1 b=0

* Extracted NMOS switches -- see file header above for the body-net
* substitution; XMSENSE's w/as/ad/ps/pd below match the corrected,
* regenerated layout (issue #32; layout/bandgap_startup/pex_extract_report.json).
* Drain/source pins (and XMKFB's gate) are wired to the exact per-terminal
* wire-parasitic hub node names layout/bandgap_startup/bandgap_startup.pex.spice's
* own M$1/M$2 cards use (M$1 = XMSENSE: det__t1/vss__t0; M$2 = XMKFB:
* fb__t0/det__t2/vss__t1 -- issue #56's re-extraction renumbered det's
* per-terminal hub indices from t0/t1 to t1/t2, since `det__t0` is now the
* newly-recognized XRPU/rhigh device's own terminal, see file header) --
* the "Wire parasitics" block below ties each hub back to its real net
* (det/fb/vss) through that file's own series R (+ ground C, no DC effect
* but included for completeness). Body stays vss directly (testbench
* fixture, unchanged -- see file header).
XMSENSE det__t1 sns1 vss__t0 vss sg13_hv_nmos w=10u l=0.5u ng=1 m=1 as=4p ad=4p ps=20.8u pd=20.8u
XMKFB fb__t0 det__t2 vss__t1 vss sg13_hv_nmos w=2u l=0.5u ng=1 m=1 as=0.8p ad=0.8p ps=4.8u pd=4.8u

* Wire parasitics (issue #37, refreshed issue #56, extended issue #59) --
* verbatim R/C cards from layout/bandgap_startup/bandgap_startup.pex.spice's
* --parasitics output (that file's M$1/M$2 cards are already re-encoded
* above as XMSENSE/XMKFB; R$3 is re-encoded above as XRPU). Issue #59 adds
* this file's own R_5_t0/C_5 (the isolated \$5/\$5__t0 net's own leg) and
* Rdet_t0 (R$3's own hub-terminal leg on `det`) -- both previously omitted
* here specifically because R$3 was not yet instantiated. `det`'s own R/C
* values below reflect the star split issue #56 already renumbered.
* Regenerate this block together with the geometry above if the layout or
* deck ever changes.
R_5_t0 \$5__t0 \$5 0.264
C_5 \$5 vsubs 1.55598e-16
Rdet_t0 det__t0 det 266.808047442
Rdet_t1 det__t1 det 139.15243699
Rdet_t2 det__t2 det 127.655815568
Cdet det vsubs 1.30736768e-13
Rfb_t0 fb__t0 fb 0.6286
Cfb fb vsubs 2.1056e-16
Rvss_t0 vss__t0 vss 5.4071
Rvss_t1 vss__t1 vss 5.4071
Cvss vss vsubs 2.34311e-15
Rvsubs_dctie vsubs 0 1e+12

.control
pre_osdi /home/ubuntu/share/pdk/ihp-sg13g2/libs.tech/ngspice/osdi/psp103.osdi
pre_osdi /home/ubuntu/share/pdk/ihp-sg13g2/libs.tech/ngspice/osdi/psp103_nqs.osdi
pre_osdi /home/ubuntu/share/pdk/ihp-sg13g2/libs.tech/ngspice/osdi/mosvar.osdi
pre_osdi /home/ubuntu/share/pdk/ihp-sg13g2/libs.tech/ngspice/osdi/r3_cmc.osdi
* 1) cold-start state: core dead (sns1 = 0), startup must be engaged.
op
print v(det) v(fb)
* 2) disengage behaviour: sweep the core's sense node up and find where the
*    detect node releases, plus the fully-running-core end state.
dc Vsns1 0 2.97 0.005
meas dc vtrip when v(det)=1.4850 cross=1
meas dc det_off find v(det) at=2.9200
meas dc fb_off find v(fb) at=2.9200
.endc
.end
