* extracted by klt extract --deck sg13cmos5l

* cell sg13cmos5l_bandgap_top
* pin d1
* pin d2
* pin det
* pin e2
* pin e3
* pin fb,out
* pin in_n,sns1
* pin in_p,sns2
* pin pn
* pin tail
* pin vdd
* pin vref
* pin vss
.SUBCKT sg13cmos5l_bandgap_top d1 d2 det e2 e3 fb|out in_n|sns1 in_p|sns2 pn
+ tail vdd vref vss
* device instance $1 r0 *1 0,80 nfet
M$1 fb|out d1 vss vss nfet L=1U W=10U AS=4P AD=4P PS=20.8U PD=20.8U
* device instance $2 r0 *1 20,80 nfet
M$2 d1 d1 vss vss nfet L=1U W=10U AS=4P AD=4P PS=20.8U PD=20.8U
* device instance $3 r0 *1 45,80 nfet
M$3 d2 d2 vss vss nfet L=1U W=10U AS=4P AD=4P PS=20.8U PD=20.8U
* device instance $4 r0 *1 65,80 nfet
M$4 pn d2 vss vss nfet L=1U W=10U AS=4P AD=4P PS=20.8U PD=20.8U
* device instance $5 r0 *1 155,80 nfet
M$5 det in_n|sns1 vss vss nfet L=0.5U W=10U AS=4P AD=4P PS=20.8U PD=20.8U
* device instance $6 r0 *1 180,80 nfet
M$6 fb|out det vss vss nfet L=0.5U W=2U AS=0.8P AD=0.8P PS=4.8U PD=4.8U
* device instance $7 r0 *1 0,60 pfet
M$7 vdd fb|out in_n|sns1 \$29 pfet L=1U W=10U AS=4P AD=4P PS=20.8U PD=20.8U
* device instance $8 r0 *1 45,60 pfet
M$8 vdd fb|out in_p|sns2 \$29 pfet L=1U W=10U AS=4P AD=4P PS=20.8U PD=20.8U
* device instance $9 r0 *1 180,60 pfet
M$9 vdd fb|out vref \$29 pfet L=1U W=10U AS=4P AD=4P PS=20.8U PD=20.8U
* device instance $10 r0 *1 20,100 pfet
M$10 tail in_p|sns2 d1 \$36 pfet L=1U W=20U AS=8P AD=8P PS=40.8U PD=40.8U
* device instance $11 r0 *1 45,100 pfet
M$11 tail in_n|sns1 d2 \$36 pfet L=1U W=20U AS=8P AD=8P PS=40.8U PD=40.8U
* device instance $12 r0 *1 20,120 pfet
M$12 vdd fb|out tail \$36 pfet L=1U W=10U AS=4P AD=4P PS=20.8U PD=20.8U
* device instance $13 r0 *1 45,120 pfet
M$13 vdd pn fb|out \$36 pfet L=1U W=10U AS=4P AD=4P PS=20.8U PD=20.8U
* device instance $14 r0 *1 70,120 pfet
M$14 vdd pn pn \$36 pfet L=1U W=10U AS=4P AD=4P PS=20.8U PD=20.8U
* device instance $15 r0 *1 52,50.925 rppd
R$15 in_p|sns2 e2 vss 11063 rppd
* device instance $16 r0 *1 199.06,35.027 rppd
R$16 vref e3 vss 84110 rppd
* device instance $17 r0 *1 122.386,109.852 rhigh
R$17 vdd det vss 1919368 rhigh
.ENDS sg13cmos5l_bandgap_top
