* Auto-generated by layout/lvs_reference.py's flatten() -- DO NOT EDIT BY HAND.
* Source: design/sg13cmos5l/netlist/bandgap_top.spice (flattened)
* Plain-element form for `klt lvs`, expanded from a hierarchical
* top-level netlist whose own X-calls are subckt instantiations,
* not devices -- see flatten()'s own docstring.
* PDK: sg13cmos5l
Mx1_M1 IN_N,SNS1 FB,OUT vdd vdd pfet L=1U W=10U
Qx1_Q1 vss vss IN_N,SNS1 pnpmpa AE=2P PE=6U M=1
Mx1_M2 IN_P,SNS2 FB,OUT vdd vdd pfet L=1U W=10U
Rx1_R2 IN_P,SNS2 e2 11064.9 rppd L=85.1U W=2U
Qx1_Q2 vss vss e2 pnpmpa AE=2P PE=6U M=8
Mx1_M3 vref FB,OUT vdd vdd pfet L=1U W=10U
Rx1_R1 vref e3 83893.4 rppd L=647U W=2U
Qx1_Q3 vss vss e3 pnpmpa AE=2P PE=6U M=1
Mx2_MTAIL tail FB,OUT vdd vdd pfet L=1U W=10U
Mx2_MP1 d1 IN_P,SNS2 tail vdd pfet L=1U W=20U
Mx2_MP2 d2 IN_N,SNS1 tail vdd pfet L=1U W=20U
Mx2_MP3 pn pn vdd vdd pfet L=1U W=10U
Mx2_MP4 FB,OUT pn vdd vdd pfet L=1U W=10U
Mx2_MN1 d1 d1 vss vss nfet L=1U W=10U
Mx2_MN2 d2 d2 vss vss nfet L=1U W=10U
Mx2_MN3 FB,OUT d1 vss vss nfet L=1U W=10U
Mx2_MN4 pn d2 vss vss nfet L=1U W=10U
Rx3_RPU vdd det 1999501.7 rhigh L=1411.3U W=1U
Mx3_MSENSE det IN_N,SNS1 vss vss nfet L=0.5U W=10U
Mx3_MKFB FB,OUT det vss vss nfet L=0.5U W=2U
.end
