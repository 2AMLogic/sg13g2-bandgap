* Auto-generated by layout/lvs_reference.py's flatten() -- DO NOT EDIT BY HAND.
* Source: design/sg13cmos5l/netlist/bandgap_top.spice (flattened)
* Plain-element form for `klt lvs`, expanded from a hierarchical
* top-level netlist whose own X-calls are subckt instantiations,
* not devices -- see flatten()'s own docstring.
* PDK: sg13cmos5l
Mx1_M1 sns1 fb vdd vdd pfet L=1U W=10U
Qx1_Q1 vss vss sns1 pnpmpa AE=2P PE=6U M=1
Mx1_M2 sns2 fb vdd vdd pfet L=1U W=10U
Rx1_R2 sns2 x1.e2 11064.9 rppd L=85.1U W=2U
Qx1_Q2 vss vss x1.e2 pnpmpa AE=2P PE=6U M=8
Mx1_M3 vref fb vdd vdd pfet L=1U W=10U
Rx1_R1 vref x1.e3 83893.4 rppd L=647U W=2U
Qx1_Q3 vss vss x1.e3 pnpmpa AE=2P PE=6U M=1
Mx2_MTAIL x2.tail fb vdd vdd pfet L=1U W=10U
Mx2_MP1 x2.d1 sns2 x2.tail vdd pfet L=1U W=20U
Mx2_MP2 x2.d2 sns1 x2.tail vdd pfet L=1U W=20U
Mx2_MP3 x2.pn x2.pn vdd vdd pfet L=1U W=10U
Mx2_MP4 fb x2.pn vdd vdd pfet L=1U W=10U
Mx2_MN1 x2.d1 x2.d1 vss vss nfet L=1U W=10U
Mx2_MN2 x2.d2 x2.d2 vss vss nfet L=1U W=10U
Mx2_MN3 fb x2.d1 vss vss nfet L=1U W=10U
Mx2_MN4 x2.pn x2.d2 vss vss nfet L=1U W=10U
Rx3_RPU vdd x3.det 1999501.7 rhigh L=1411.3U W=1U
Mx3_MSENSE x3.det sns1 vss vss nfet L=0.5U W=10U
Mx3_MKFB fb x3.det vss vss nfet L=0.5U W=2U
.end
