* Auto-generated by layout/lvs_reference.py -- DO NOT EDIT BY HAND.
* Source: design/sg13cmos5l/netlist/bandgap_startup.spice
* Plain-element form for `klt lvs` (see this file's own module
* docstring for why the subckt-call form above cannot be used
* directly, and why klt's own `reference.form: "subckt-call"`
* converter cannot handle this circuit's mixed MOS/BJT/resistor
* device set either).
* PDK: sg13cmos5l
RPU vdd det 1999501.7 rhigh L=1411.3U W=1U
MSENSE det sns1 vss vss nfet L=0.5U W=10U
MKFB fb det vss vss nfet L=0.5U W=2U
.end
