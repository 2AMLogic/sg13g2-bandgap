* Auto-generated by layout/lvs_reference.py -- DO NOT EDIT BY HAND.
* Source: design/sg13cmos5l/netlist/bandgap_amp.spice
* Plain-element form for `klt lvs` (see this file's own module
* docstring for why the subckt-call form above cannot be used
* directly, and why klt's own `reference.form: "subckt-call"`
* converter cannot handle this circuit's mixed MOS/BJT/resistor
* device set either).
* PDK: sg13cmos5l
MTAIL tail out vdd vdd pfet L=1U W=10U
MP1 d1 in_p tail vdd pfet L=1U W=20U
MP2 d2 in_n tail vdd pfet L=1U W=20U
MP3 pn pn vdd vdd pfet L=1U W=10U
MP4 out pn vdd vdd pfet L=1U W=10U
MN1 d1 d1 vss vss nfet L=1U W=10U
MN2 d2 d2 vss vss nfet L=1U W=10U
MN3 out d1 vss vss nfet L=1U W=10U
MN4 pn d2 vss vss nfet L=1U W=10U
.end
