* Single-device source netlist for the runset-LVS fixture (issue #380): one
* npn13G2 at Nx=1 in the shape design/netlist/bandgap_core.spice
* instantiates (Q1, diode-connected, emitter on vss, substrate on its own pin).
.subckt npn13g2 sns1 vss sub
XQ1 sns1 sns1 vss sub npn13G2 Nx=1
.ends
