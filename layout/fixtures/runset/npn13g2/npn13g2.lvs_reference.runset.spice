* Auto-generated by layout/lvs_reference.py -- DO NOT EDIT BY HAND.
* Source: layout/fixtures/runset/npn13g2/npn13g2.spice
* PDK: sg13g2-runset
.subckt npn13g2 sns1 vss sub
Q1 sns1 sns1 vss sub npn13G2 le=900.0n we=70.00n m=1
.ends
.end
