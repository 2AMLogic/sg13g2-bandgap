* Auto-generated by layout/lvs_reference.py -- DO NOT EDIT BY HAND.
* Source: layout/fixtures/runset/hv_nmos/hv_nmos.spice
* PDK: sg13g2-runset
.subckt hv_nmos det sns1 vss
MSENSE det sns1 vss vss sg13_hv_nmos w=10u l=0.5u ng=1 m=1
.ends
.end
