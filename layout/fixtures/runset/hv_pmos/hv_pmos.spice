* Single-device source netlist for the runset-LVS fixture (issue #380): one
* HV PMOS in the shape design/netlist/bandgap_core.spice instantiates (M1).
.subckt hv_pmos d g vdd
XM1 d g vdd vdd sg13_hv_pmos w=10u l=1u ng=1 m=1
.ends
