* Auto-generated by layout/lvs_reference.py -- DO NOT EDIT BY HAND.
* Source: layout/fixtures/runset/hv_pmos/hv_pmos.spice
* PDK: sg13g2-runset
.subckt hv_pmos d g vdd
M1 d g vdd vdd sg13_hv_pmos w=10u l=1u ng=1 m=1
.ends
.end
