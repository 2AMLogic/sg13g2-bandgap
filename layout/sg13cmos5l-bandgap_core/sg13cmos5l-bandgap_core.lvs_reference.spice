* Auto-generated by layout/lvs_reference.py -- DO NOT EDIT BY HAND.
* Source: design/sg13cmos5l/netlist/bandgap_core.spice
* Plain-element form for `klt lvs` (see this file's own module
* docstring for why the subckt-call form above cannot be used
* directly, and why klt's own `reference.form: "subckt-call"`
* converter cannot handle this circuit's mixed MOS/BJT/resistor
* device set either).
* PDK: sg13cmos5l
M1 sns1 fb vdd vdd pfet L=1U W=10U
Q1 vss vss sns1 pnpmpa AE=2P PE=6U
M2 sns2 fb vdd vdd pfet L=1U W=10U
R2 sns2 e2 11064.9 rppd L=85.1U W=2U
Q2 vss vss e2 pnpmpa AE=16P PE=20U
M3 vref fb vdd vdd pfet L=1U W=10U
R1 vref e3 83893.4 rppd L=647U W=2U
Q3 vss vss e3 pnpmpa AE=2P PE=6U
.end
