* Auto-generated by layout/lvs_reference.py's flatten() -- DO NOT EDIT BY HAND.
* Source: design/netlist/bandgap_top.spice (flattened)
* Plain-element form for `klt lvs`, expanded from a hierarchical
* top-level netlist whose own X-calls are subckt instantiations,
* not devices -- see flatten()'s own docstring.
* PDK: sg13g2-runset
.subckt bandgap_top vdd vss vref
Mx1_M1 IN_N,SNS1 FB,OUT vdd vdd sg13_hv_pmos w=10u l=1u ng=1 m=1
Qx1_Q1 IN_N,SNS1 IN_N,SNS1 vss vss npn13G2 le=900.0n we=70.00n m=1
Mx1_M2A IN_P,SNS2 FB,OUT vdd vdd sg13_hv_pmos w=9u l=1u ng=1 m=1
Mx1_M2B IN_P,SNS2 FB,OUT vdd vdd sg13_hv_pmos w=1u l=1u ng=1 m=1
Rx1_R2 IN_P,SNS2 cb2 x1.sub! rppd l=82.7u w=2u
Qx1_Q2 cb2 cb2 vss vss npn13G2 le=900.0n we=70.00n m=8
Mx1_M3A vref FB,OUT vdd vdd sg13_hv_pmos w=8u l=1u ng=1 m=1
Mx1_M3B vref FB,OUT vdd vdd sg13_hv_pmos w=1u l=1u ng=1 m=1
Mx1_M3C vref FB,OUT vdd vdd sg13_hv_pmos w=1u l=1u ng=1 m=1
Rx1_R1 vref T001,T003,T007,T015,T031,T063,T127,TN0 x1.sub! rppd l=37.2u w=2u
RU1 T001,T003,T007,T015,T031,T063,T127,TN0 T001,T003,T007,T015,T031,T063,T127,TN0 x1.sub! rppd l=3.43u w=2u
RU2 T001,T003,T007,T015,T031,T063,T127,TN0 t002 x1.sub! rppd l=3.43u w=2u
RU3 t002 T001,T003,T007,T015,T031,T063,T127,TN0 x1.sub! rppd l=3.43u w=2u
RU4 T001,T003,T007,T015,T031,T063,T127,TN0 t004 x1.sub! rppd l=3.43u w=2u
RU5 t004 t005 x1.sub! rppd l=3.43u w=2u
RU6 t005 t006 x1.sub! rppd l=3.43u w=2u
RU7 t006 T001,T003,T007,T015,T031,T063,T127,TN0 x1.sub! rppd l=3.43u w=2u
RU8 T001,T003,T007,T015,T031,T063,T127,TN0 t008 x1.sub! rppd l=3.43u w=2u
RU9 t008 t009 x1.sub! rppd l=3.43u w=2u
RU10 t009 t010 x1.sub! rppd l=3.43u w=2u
RU11 t010 t011 x1.sub! rppd l=3.43u w=2u
RU12 t011 t012 x1.sub! rppd l=3.43u w=2u
RU13 t012 t013 x1.sub! rppd l=3.43u w=2u
RU14 t013 t014 x1.sub! rppd l=3.43u w=2u
RU15 t014 T001,T003,T007,T015,T031,T063,T127,TN0 x1.sub! rppd l=3.43u w=2u
RU16 T001,T003,T007,T015,T031,T063,T127,TN0 t016 x1.sub! rppd l=3.43u w=2u
RU17 t016 t017 x1.sub! rppd l=3.43u w=2u
RU18 t017 t018 x1.sub! rppd l=3.43u w=2u
RU19 t018 t019 x1.sub! rppd l=3.43u w=2u
RU20 t019 t020 x1.sub! rppd l=3.43u w=2u
RU21 t020 t021 x1.sub! rppd l=3.43u w=2u
RU22 t021 t022 x1.sub! rppd l=3.43u w=2u
RU23 t022 t023 x1.sub! rppd l=3.43u w=2u
RU24 t023 t024 x1.sub! rppd l=3.43u w=2u
RU25 t024 t025 x1.sub! rppd l=3.43u w=2u
RU26 t025 t026 x1.sub! rppd l=3.43u w=2u
RU27 t026 t027 x1.sub! rppd l=3.43u w=2u
RU28 t027 t028 x1.sub! rppd l=3.43u w=2u
RU29 t028 t029 x1.sub! rppd l=3.43u w=2u
RU30 t029 t030 x1.sub! rppd l=3.43u w=2u
RU31 t030 T001,T003,T007,T015,T031,T063,T127,TN0 x1.sub! rppd l=3.43u w=2u
RU32 T001,T003,T007,T015,T031,T063,T127,TN0 t032 x1.sub! rppd l=3.43u w=2u
RU33 t032 t033 x1.sub! rppd l=3.43u w=2u
RU34 t033 t034 x1.sub! rppd l=3.43u w=2u
RU35 t034 t035 x1.sub! rppd l=3.43u w=2u
RU36 t035 t036 x1.sub! rppd l=3.43u w=2u
RU37 t036 t037 x1.sub! rppd l=3.43u w=2u
RU38 t037 t038 x1.sub! rppd l=3.43u w=2u
RU39 t038 t039 x1.sub! rppd l=3.43u w=2u
RU40 t039 t040 x1.sub! rppd l=3.43u w=2u
RU41 t040 t041 x1.sub! rppd l=3.43u w=2u
RU42 t041 t042 x1.sub! rppd l=3.43u w=2u
RU43 t042 t043 x1.sub! rppd l=3.43u w=2u
RU44 t043 t044 x1.sub! rppd l=3.43u w=2u
RU45 t044 t045 x1.sub! rppd l=3.43u w=2u
RU46 t045 t046 x1.sub! rppd l=3.43u w=2u
RU47 t046 t047 x1.sub! rppd l=3.43u w=2u
RU48 t047 t048 x1.sub! rppd l=3.43u w=2u
RU49 t048 t049 x1.sub! rppd l=3.43u w=2u
RU50 t049 t050 x1.sub! rppd l=3.43u w=2u
RU51 t050 t051 x1.sub! rppd l=3.43u w=2u
RU52 t051 t052 x1.sub! rppd l=3.43u w=2u
RU53 t052 t053 x1.sub! rppd l=3.43u w=2u
RU54 t053 t054 x1.sub! rppd l=3.43u w=2u
RU55 t054 t055 x1.sub! rppd l=3.43u w=2u
RU56 t055 t056 x1.sub! rppd l=3.43u w=2u
RU57 t056 t057 x1.sub! rppd l=3.43u w=2u
RU58 t057 t058 x1.sub! rppd l=3.43u w=2u
RU59 t058 t059 x1.sub! rppd l=3.43u w=2u
RU60 t059 t060 x1.sub! rppd l=3.43u w=2u
RU61 t060 t061 x1.sub! rppd l=3.43u w=2u
RU62 t061 t062 x1.sub! rppd l=3.43u w=2u
RU63 t062 T001,T003,T007,T015,T031,T063,T127,TN0 x1.sub! rppd l=3.43u w=2u
RU64 T001,T003,T007,T015,T031,T063,T127,TN0 t064 x1.sub! rppd l=3.43u w=2u
RU65 t064 t065 x1.sub! rppd l=3.43u w=2u
RU66 t065 t066 x1.sub! rppd l=3.43u w=2u
RU67 t066 t067 x1.sub! rppd l=3.43u w=2u
RU68 t067 t068 x1.sub! rppd l=3.43u w=2u
RU69 t068 t069 x1.sub! rppd l=3.43u w=2u
RU70 t069 t070 x1.sub! rppd l=3.43u w=2u
RU71 t070 t071 x1.sub! rppd l=3.43u w=2u
RU72 t071 t072 x1.sub! rppd l=3.43u w=2u
RU73 t072 t073 x1.sub! rppd l=3.43u w=2u
RU74 t073 t074 x1.sub! rppd l=3.43u w=2u
RU75 t074 t075 x1.sub! rppd l=3.43u w=2u
RU76 t075 t076 x1.sub! rppd l=3.43u w=2u
RU77 t076 t077 x1.sub! rppd l=3.43u w=2u
RU78 t077 t078 x1.sub! rppd l=3.43u w=2u
RU79 t078 t079 x1.sub! rppd l=3.43u w=2u
RU80 t079 t080 x1.sub! rppd l=3.43u w=2u
RU81 t080 t081 x1.sub! rppd l=3.43u w=2u
RU82 t081 t082 x1.sub! rppd l=3.43u w=2u
RU83 t082 t083 x1.sub! rppd l=3.43u w=2u
RU84 t083 t084 x1.sub! rppd l=3.43u w=2u
RU85 t084 t085 x1.sub! rppd l=3.43u w=2u
RU86 t085 t086 x1.sub! rppd l=3.43u w=2u
RU87 t086 t087 x1.sub! rppd l=3.43u w=2u
RU88 t087 t088 x1.sub! rppd l=3.43u w=2u
RU89 t088 t089 x1.sub! rppd l=3.43u w=2u
RU90 t089 t090 x1.sub! rppd l=3.43u w=2u
RU91 t090 t091 x1.sub! rppd l=3.43u w=2u
RU92 t091 t092 x1.sub! rppd l=3.43u w=2u
RU93 t092 t093 x1.sub! rppd l=3.43u w=2u
RU94 t093 t094 x1.sub! rppd l=3.43u w=2u
RU95 t094 t095 x1.sub! rppd l=3.43u w=2u
RU96 t095 t096 x1.sub! rppd l=3.43u w=2u
RU97 t096 t097 x1.sub! rppd l=3.43u w=2u
RU98 t097 t098 x1.sub! rppd l=3.43u w=2u
RU99 t098 t099 x1.sub! rppd l=3.43u w=2u
RU100 t099 t100 x1.sub! rppd l=3.43u w=2u
RU101 t100 t101 x1.sub! rppd l=3.43u w=2u
RU102 t101 t102 x1.sub! rppd l=3.43u w=2u
RU103 t102 t103 x1.sub! rppd l=3.43u w=2u
RU104 t103 t104 x1.sub! rppd l=3.43u w=2u
RU105 t104 t105 x1.sub! rppd l=3.43u w=2u
RU106 t105 t106 x1.sub! rppd l=3.43u w=2u
RU107 t106 t107 x1.sub! rppd l=3.43u w=2u
RU108 t107 t108 x1.sub! rppd l=3.43u w=2u
RU109 t108 t109 x1.sub! rppd l=3.43u w=2u
RU110 t109 t110 x1.sub! rppd l=3.43u w=2u
RU111 t110 t111 x1.sub! rppd l=3.43u w=2u
RU112 t111 t112 x1.sub! rppd l=3.43u w=2u
RU113 t112 t113 x1.sub! rppd l=3.43u w=2u
RU114 t113 t114 x1.sub! rppd l=3.43u w=2u
RU115 t114 t115 x1.sub! rppd l=3.43u w=2u
RU116 t115 t116 x1.sub! rppd l=3.43u w=2u
RU117 t116 t117 x1.sub! rppd l=3.43u w=2u
RU118 t117 t118 x1.sub! rppd l=3.43u w=2u
RU119 t118 t119 x1.sub! rppd l=3.43u w=2u
RU120 t119 t120 x1.sub! rppd l=3.43u w=2u
RU121 t120 t121 x1.sub! rppd l=3.43u w=2u
RU122 t121 t122 x1.sub! rppd l=3.43u w=2u
RU123 t122 t123 x1.sub! rppd l=3.43u w=2u
RU124 t123 t124 x1.sub! rppd l=3.43u w=2u
RU125 t124 t125 x1.sub! rppd l=3.43u w=2u
RU126 t125 t126 x1.sub! rppd l=3.43u w=2u
RU127 t126 T001,T003,T007,T015,T031,T063,T127,TN0 x1.sub! rppd l=3.43u w=2u
RU128 T001,T003,T007,T015,T031,T063,T127,TN0 t128 x1.sub! rppd l=3.43u w=2u
RU129 t128 t129 x1.sub! rppd l=3.43u w=2u
RU130 t129 t130 x1.sub! rppd l=3.43u w=2u
RU131 t130 t131 x1.sub! rppd l=3.43u w=2u
RU132 t131 t132 x1.sub! rppd l=3.43u w=2u
RU133 t132 t133 x1.sub! rppd l=3.43u w=2u
RU134 t133 t134 x1.sub! rppd l=3.43u w=2u
RU135 t134 t135 x1.sub! rppd l=3.43u w=2u
RU136 t135 t136 x1.sub! rppd l=3.43u w=2u
RU137 t136 t137 x1.sub! rppd l=3.43u w=2u
RU138 t137 t138 x1.sub! rppd l=3.43u w=2u
RU139 t138 t139 x1.sub! rppd l=3.43u w=2u
RU140 t139 t140 x1.sub! rppd l=3.43u w=2u
RU141 t140 t141 x1.sub! rppd l=3.43u w=2u
RU142 t141 t142 x1.sub! rppd l=3.43u w=2u
RU143 t142 t143 x1.sub! rppd l=3.43u w=2u
RU144 t143 t144 x1.sub! rppd l=3.43u w=2u
RU145 t144 t145 x1.sub! rppd l=3.43u w=2u
RU146 t145 t146 x1.sub! rppd l=3.43u w=2u
RU147 t146 t147 x1.sub! rppd l=3.43u w=2u
RU148 t147 t148 x1.sub! rppd l=3.43u w=2u
RU149 t148 t149 x1.sub! rppd l=3.43u w=2u
RU150 t149 t150 x1.sub! rppd l=3.43u w=2u
RU151 t150 t151 x1.sub! rppd l=3.43u w=2u
RU152 t151 t152 x1.sub! rppd l=3.43u w=2u
RU153 t152 t153 x1.sub! rppd l=3.43u w=2u
RU154 t153 t154 x1.sub! rppd l=3.43u w=2u
RU155 t154 t155 x1.sub! rppd l=3.43u w=2u
RU156 t155 t156 x1.sub! rppd l=3.43u w=2u
RU157 t156 t157 x1.sub! rppd l=3.43u w=2u
RU158 t157 t158 x1.sub! rppd l=3.43u w=2u
RU159 t158 t159 x1.sub! rppd l=3.43u w=2u
RU160 t159 t160 x1.sub! rppd l=3.43u w=2u
RU161 t160 t161 x1.sub! rppd l=3.43u w=2u
RU162 t161 t162 x1.sub! rppd l=3.43u w=2u
RU163 t162 t163 x1.sub! rppd l=3.43u w=2u
RU164 t163 t164 x1.sub! rppd l=3.43u w=2u
RU165 t164 t165 x1.sub! rppd l=3.43u w=2u
RU166 t165 t166 x1.sub! rppd l=3.43u w=2u
RU167 t166 t167 x1.sub! rppd l=3.43u w=2u
RU168 t167 t168 x1.sub! rppd l=3.43u w=2u
RU169 t168 t169 x1.sub! rppd l=3.43u w=2u
RU170 t169 t170 x1.sub! rppd l=3.43u w=2u
RU171 t170 t171 x1.sub! rppd l=3.43u w=2u
RU172 t171 t172 x1.sub! rppd l=3.43u w=2u
RU173 t172 t173 x1.sub! rppd l=3.43u w=2u
RU174 t173 t174 x1.sub! rppd l=3.43u w=2u
RU175 t174 t175 x1.sub! rppd l=3.43u w=2u
RU176 t175 t176 x1.sub! rppd l=3.43u w=2u
RU177 t176 t177 x1.sub! rppd l=3.43u w=2u
RU178 t177 t178 x1.sub! rppd l=3.43u w=2u
RU179 t178 t179 x1.sub! rppd l=3.43u w=2u
RU180 t179 t180 x1.sub! rppd l=3.43u w=2u
RU181 t180 t181 x1.sub! rppd l=3.43u w=2u
RU182 t181 t182 x1.sub! rppd l=3.43u w=2u
RU183 t182 t183 x1.sub! rppd l=3.43u w=2u
RU184 t183 t184 x1.sub! rppd l=3.43u w=2u
RU185 t184 t185 x1.sub! rppd l=3.43u w=2u
RU186 t185 t186 x1.sub! rppd l=3.43u w=2u
RU187 t186 t187 x1.sub! rppd l=3.43u w=2u
RU188 t187 t188 x1.sub! rppd l=3.43u w=2u
RU189 t188 t189 x1.sub! rppd l=3.43u w=2u
RU190 t189 t190 x1.sub! rppd l=3.43u w=2u
RU191 t190 t191 x1.sub! rppd l=3.43u w=2u
RU192 t191 t192 x1.sub! rppd l=3.43u w=2u
RU193 t192 t193 x1.sub! rppd l=3.43u w=2u
RU194 t193 t194 x1.sub! rppd l=3.43u w=2u
RU195 t194 t195 x1.sub! rppd l=3.43u w=2u
RU196 t195 t196 x1.sub! rppd l=3.43u w=2u
RU197 t196 t197 x1.sub! rppd l=3.43u w=2u
RU198 t197 t198 x1.sub! rppd l=3.43u w=2u
RU199 t198 t199 x1.sub! rppd l=3.43u w=2u
RU200 t199 t200 x1.sub! rppd l=3.43u w=2u
RU201 t200 t201 x1.sub! rppd l=3.43u w=2u
RU202 t201 t202 x1.sub! rppd l=3.43u w=2u
RU203 t202 t203 x1.sub! rppd l=3.43u w=2u
RU204 t203 t204 x1.sub! rppd l=3.43u w=2u
RU205 t204 t205 x1.sub! rppd l=3.43u w=2u
RU206 t205 t206 x1.sub! rppd l=3.43u w=2u
RU207 t206 t207 x1.sub! rppd l=3.43u w=2u
RU208 t207 t208 x1.sub! rppd l=3.43u w=2u
RU209 t208 t209 x1.sub! rppd l=3.43u w=2u
RU210 t209 t210 x1.sub! rppd l=3.43u w=2u
RU211 t210 t211 x1.sub! rppd l=3.43u w=2u
RU212 t211 t212 x1.sub! rppd l=3.43u w=2u
RU213 t212 t213 x1.sub! rppd l=3.43u w=2u
RU214 t213 t214 x1.sub! rppd l=3.43u w=2u
RU215 t214 t215 x1.sub! rppd l=3.43u w=2u
RU216 t215 t216 x1.sub! rppd l=3.43u w=2u
RU217 t216 t217 x1.sub! rppd l=3.43u w=2u
RU218 t217 t218 x1.sub! rppd l=3.43u w=2u
RU219 t218 t219 x1.sub! rppd l=3.43u w=2u
RU220 t219 t220 x1.sub! rppd l=3.43u w=2u
RU221 t220 t221 x1.sub! rppd l=3.43u w=2u
RU222 t221 t222 x1.sub! rppd l=3.43u w=2u
RU223 t222 t223 x1.sub! rppd l=3.43u w=2u
RU224 t223 t224 x1.sub! rppd l=3.43u w=2u
RU225 t224 t225 x1.sub! rppd l=3.43u w=2u
RU226 t225 t226 x1.sub! rppd l=3.43u w=2u
RU227 t226 t227 x1.sub! rppd l=3.43u w=2u
RU228 t227 t228 x1.sub! rppd l=3.43u w=2u
RU229 t228 t229 x1.sub! rppd l=3.43u w=2u
RU230 t229 t230 x1.sub! rppd l=3.43u w=2u
RU231 t230 t231 x1.sub! rppd l=3.43u w=2u
RU232 t231 t232 x1.sub! rppd l=3.43u w=2u
RU233 t232 t233 x1.sub! rppd l=3.43u w=2u
RU234 t233 t234 x1.sub! rppd l=3.43u w=2u
RU235 t234 t235 x1.sub! rppd l=3.43u w=2u
RU236 t235 t236 x1.sub! rppd l=3.43u w=2u
RU237 t236 t237 x1.sub! rppd l=3.43u w=2u
RU238 t237 t238 x1.sub! rppd l=3.43u w=2u
RU239 t238 t239 x1.sub! rppd l=3.43u w=2u
RU240 t239 t240 x1.sub! rppd l=3.43u w=2u
RU241 t240 t241 x1.sub! rppd l=3.43u w=2u
RU242 t241 t242 x1.sub! rppd l=3.43u w=2u
RU243 t242 t243 x1.sub! rppd l=3.43u w=2u
RU244 t243 t244 x1.sub! rppd l=3.43u w=2u
RU245 t244 t245 x1.sub! rppd l=3.43u w=2u
RU246 t245 t246 x1.sub! rppd l=3.43u w=2u
RU247 t246 t247 x1.sub! rppd l=3.43u w=2u
RU248 t247 t248 x1.sub! rppd l=3.43u w=2u
RU249 t248 t249 x1.sub! rppd l=3.43u w=2u
RU250 t249 t250 x1.sub! rppd l=3.43u w=2u
RU251 t250 t251 x1.sub! rppd l=3.43u w=2u
RU252 t251 t252 x1.sub! rppd l=3.43u w=2u
RU253 t252 t253 x1.sub! rppd l=3.43u w=2u
RU254 t253 t254 x1.sub! rppd l=3.43u w=2u
RU255 t254 cb3 x1.sub! rppd l=3.43u w=2u
Qx1_Q3 cb3 cb3 vss vss npn13G2 le=900.0n we=70.00n m=1
Mx2_MTAIL tail FB,OUT vdd vdd sg13_hv_pmos w=10u l=1u ng=1 m=1
Mx2_MP1 d1 IN_P,SNS2 tail vdd sg13_hv_pmos w=20u l=1u ng=1 m=1
Mx2_MP2 d2 IN_N,SNS1 tail vdd sg13_hv_pmos w=20u l=1u ng=1 m=1
Mx2_MP3 pn pn vdd vdd sg13_hv_pmos w=10u l=1u ng=1 m=1
Mx2_MP4 FB,OUT pn vdd vdd sg13_hv_pmos w=10u l=1u ng=1 m=1
Mx2_MN1 d1 d1 vss vss sg13_hv_nmos w=10u l=1u ng=1 m=1
Mx2_MN2 d2 d2 vss vss sg13_hv_nmos w=10u l=1u ng=1 m=1
Mx2_MN3 FB,OUT d1 vss vss sg13_hv_nmos w=10u l=1u ng=1 m=1
Mx2_MN4 pn d2 vss vss sg13_hv_nmos w=10u l=1u ng=1 m=1
Rx3_RPU vdd det x3.sub! rhigh l=1411.3u w=1u
Mx3_MSENSE det IN_N,SNS1 vss vss sg13_hv_nmos w=10u l=0.5u ng=1 m=1
Mx3_MKFB FB,OUT det vss vss sg13_hv_nmos w=2u l=0.5u ng=1 m=1
.ends
.end
