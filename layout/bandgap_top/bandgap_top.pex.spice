* extracted by klt extract --deck sg13g2
* parasitic model (--parasitics):
* - capacitance: net-to-ground for every net's own (non-coupled) area/perimeter, plus net-to-net for the vertical-overlap coupling `coupling` describes below -- a coupled net pair gets a direct capacitor between their two hub nodes, not just capacitors to the deck's ground/substrate net
* - coupling: vertical overlap (crossover) unconditionally -- where one net's conductor on an adjacent metal level sits directly over another *distinct* net's conductor, that overlap area is charged between the two nets instead of to ground (issue #760) -- plus lateral (same-layer, sidewall) coupling, but only for a net pair naming one of the caller's declared `--critical-net` nets (issue #976): facing-edge length within that layer's own minimum-spacing lookback is charged between the two nets, *additively* (not deducted from either net's substrate fringe term, unlike the vertical case -- a known simplification). Any same-layer pair with neither side named `--critical-net`, and fringe shielding in general, are still not modelled
* - resistance: single lumped series resistance per net, distributed as a star across that net's device terminals (issue #592) -- not a per-segment, distributed RC ladder, *unless* `--distributed-rc` names this net via `--critical-net` (issue #977, Epic #709 Phase 2b): then the net's terminals are ordered along their approximate physical spread and its total R/C is broken into a chain of per-segment resistors (segment length proportional to inter-terminal distance) with a ground capacitor at each terminal node (proportional to its adjacent segment length/2), instead of one star hub -- still an approximation (terminal position is a device-placement proxy, not true per-segment routing geometry), but a strictly finer-grained one than the single-hub star
* - frequency: quasi-static -- one frequency-independent R and C per net; no skin effect, no distributed transmission-line behavior
* - substrate tie: 1e+12 ohm to ground -- the substrate is capacitively floating in transient analysis (DC reference only); see --substrate-tie-ohms
.GLOBAL vsubs

* cell bandgap_top
* pin CB2
* pin CB3
* pin D1
* pin D2
* pin DET
* pin FB,OUT
* pin IN_N,SNS1
* pin IN_P,SNS2
* pin PN
* pin T001,T003,T007,T015,T031,T063,T127,TN0
* pin T002
* pin T004
* pin T005
* pin T006
* pin T008
* pin T009
* pin T010
* pin T011
* pin T012
* pin T013
* pin T014
* pin T016
* pin T017
* pin T018
* pin T019
* pin T020
* pin T021
* pin T022
* pin T023
* pin T024
* pin T025
* pin T026
* pin T027
* pin T028
* pin T029
* pin T030
* pin T032
* pin T033
* pin T034
* pin T035
* pin T036
* pin T037
* pin T038
* pin T039
* pin T040
* pin T041
* pin T042
* pin T043
* pin T044
* pin T045
* pin T046
* pin T047
* pin T048
* pin T049
* pin T050
* pin T051
* pin T052
* pin T053
* pin T054
* pin T055
* pin T056
* pin T057
* pin T058
* pin T059
* pin T060
* pin T061
* pin T062
* pin T064
* pin T065
* pin T066
* pin T067
* pin T068
* pin T069
* pin T070
* pin T071
* pin T072
* pin T073
* pin T074
* pin T075
* pin T076
* pin T077
* pin T078
* pin T079
* pin T080
* pin T081
* pin T082
* pin T083
* pin T084
* pin T085
* pin T086
* pin T087
* pin T088
* pin T089
* pin T090
* pin T091
* pin T092
* pin T093
* pin T094
* pin T095
* pin T096
* pin T097
* pin T098
* pin T099
* pin T100
* pin T101
* pin T102
* pin T103
* pin T104
* pin T105
* pin T106
* pin T107
* pin T108
* pin T109
* pin T110
* pin T111
* pin T112
* pin T113
* pin T114
* pin T115
* pin T116
* pin T117
* pin T118
* pin T119
* pin T120
* pin T121
* pin T122
* pin T123
* pin T124
* pin T125
* pin T126
* pin T128
* pin T129
* pin T130
* pin T131
* pin T132
* pin T133
* pin T134
* pin T135
* pin T136
* pin T137
* pin T138
* pin T139
* pin T140
* pin T141
* pin T142
* pin T143
* pin T144
* pin T145
* pin T146
* pin T147
* pin T148
* pin T149
* pin T150
* pin T151
* pin T152
* pin T153
* pin T154
* pin T155
* pin T156
* pin T157
* pin T158
* pin T159
* pin T160
* pin T161
* pin T162
* pin T163
* pin T164
* pin T165
* pin T166
* pin T167
* pin T168
* pin T169
* pin T170
* pin T171
* pin T172
* pin T173
* pin T174
* pin T175
* pin T176
* pin T177
* pin T178
* pin T179
* pin T180
* pin T181
* pin T182
* pin T183
* pin T184
* pin T185
* pin T186
* pin T187
* pin T188
* pin T189
* pin T190
* pin T191
* pin T192
* pin T193
* pin T194
* pin T195
* pin T196
* pin T197
* pin T198
* pin T199
* pin T200
* pin T201
* pin T202
* pin T203
* pin T204
* pin T205
* pin T206
* pin T207
* pin T208
* pin T209
* pin T210
* pin T211
* pin T212
* pin T213
* pin T214
* pin T215
* pin T216
* pin T217
* pin T218
* pin T219
* pin T220
* pin T221
* pin T222
* pin T223
* pin T224
* pin T225
* pin T226
* pin T227
* pin T228
* pin T229
* pin T230
* pin T231
* pin T232
* pin T233
* pin T234
* pin T235
* pin T236
* pin T237
* pin T238
* pin T239
* pin T240
* pin T241
* pin T242
* pin T243
* pin T244
* pin T245
* pin T246
* pin T247
* pin T248
* pin T249
* pin T250
* pin T251
* pin T252
* pin T253
* pin T254
* pin TAIL
* pin VDD
* pin VREF
* pin VSS
.SUBCKT bandgap_top CB2 CB3 D1 D2 DET FB|OUT IN_N|SNS1 IN_P|SNS2 PN
+ T001|T003|T007|T015|T031|T063|T127|TN0 T002 T004 T005 T006 T008 T009 T010
+ T011 T012 T013 T014 T016 T017 T018 T019 T020 T021 T022 T023 T024 T025 T026
+ T027 T028 T029 T030 T032 T033 T034 T035 T036 T037 T038 T039 T040 T041 T042
+ T043 T044 T045 T046 T047 T048 T049 T050 T051 T052 T053 T054 T055 T056 T057
+ T058 T059 T060 T061 T062 T064 T065 T066 T067 T068 T069 T070 T071 T072 T073
+ T074 T075 T076 T077 T078 T079 T080 T081 T082 T083 T084 T085 T086 T087 T088
+ T089 T090 T091 T092 T093 T094 T095 T096 T097 T098 T099 T100 T101 T102 T103
+ T104 T105 T106 T107 T108 T109 T110 T111 T112 T113 T114 T115 T116 T117 T118
+ T119 T120 T121 T122 T123 T124 T125 T126 T128 T129 T130 T131 T132 T133 T134
+ T135 T136 T137 T138 T139 T140 T141 T142 T143 T144 T145 T146 T147 T148 T149
+ T150 T151 T152 T153 T154 T155 T156 T157 T158 T159 T160 T161 T162 T163 T164
+ T165 T166 T167 T168 T169 T170 T171 T172 T173 T174 T175 T176 T177 T178 T179
+ T180 T181 T182 T183 T184 T185 T186 T187 T188 T189 T190 T191 T192 T193 T194
+ T195 T196 T197 T198 T199 T200 T201 T202 T203 T204 T205 T206 T207 T208 T209
+ T210 T211 T212 T213 T214 T215 T216 T217 T218 T219 T220 T221 T222 T223 T224
+ T225 T226 T227 T228 T229 T230 T231 T232 T233 T234 T235 T236 T237 T238 T239
+ T240 T241 T242 T243 T244 T245 T246 T247 T248 T249 T250 T251 T252 T253 T254
+ TAIL VDD VREF VSS
* device instance $1 r0 *1 0,0 nfet
M$1 D1__t0 D1__t1 VSS__t0 VSS__t264 nfet L=1U W=10U AS=4P AD=4P PS=20.8U
+ PD=20.8U
* device instance $2 r0 *1 40,0 nfet
M$2 D2__t3 D2__t2 VSS__t4 VSS__t265 nfet L=1U W=10U AS=4P AD=4P PS=20.8U
+ PD=20.8U
* device instance $3 r0 *1 140,0 nfet
M$3 FB|OUT__t9 D1__t3 VSS__t5 VSS__t266 nfet L=1U W=10U AS=4P AD=4P PS=20.8U
+ PD=20.8U
* device instance $4 r0 *1 200,0 nfet
M$4 PN__t3 D2__t1 VSS__t3 VSS__t267 nfet L=1U W=10U AS=4P AD=4P PS=20.8U
+ PD=20.8U
* device instance $5 r0 *1 208,53 nfet
M$5 DET__t0 IN_N|SNS1__t0 VSS__t1 VSS__t268 nfet L=0.5U W=10U AS=4P AD=4P
+ PS=20.8U PD=20.8U
* device instance $6 r0 *1 228,53 nfet
M$6 FB|OUT__t1 DET__t2 VSS__t2 VSS__t269 nfet L=0.5U W=2U AS=0.8P AD=0.8P
+ PS=4.8U PD=4.8U
* device instance $7 r0 *1 0,30 pfet
M$7 TAIL__t0 IN_P|SNS2__t0 D1__t2 VDD__t0 pfet L=1U W=20U AS=8P AD=8P PS=40.8U
+ PD=40.8U
* device instance $8 r0 *1 40,30 pfet
M$8 TAIL__t2 IN_N|SNS1__t2 D2__t0 VDD__t20 pfet L=1U W=20U AS=8P AD=8P PS=40.8U
+ PD=40.8U
* device instance $9 r0 *1 80,30 pfet
M$9 VDD__t1 FB|OUT__t0 TAIL__t1 VDD__t2 pfet L=1U W=10U AS=4P AD=4P PS=20.8U
+ PD=20.8U
* device instance $10 r0 *1 110,30 pfet
M$10 VDD__t18 PN__t0 PN__t2 VDD__t15 pfet L=1U W=10U AS=4P AD=4P PS=20.8U
+ PD=20.8U
* device instance $11 r0 *1 140,30 pfet
M$11 VDD__t19 PN__t1 FB|OUT__t8 VDD__t16 pfet L=1U W=10U AS=4P AD=4P PS=20.8U
+ PD=20.8U
* device instance $12 r0 *1 0,75 pfet
M$12 VDD__t17 FB|OUT__t7 IN_N|SNS1__t1 VDD__t14 pfet L=1U W=10U AS=4P AD=4P
+ PS=20.8U PD=20.8U
* device instance $13 r0 *1 45,75 pfet
M$13 VDD__t4 FB|OUT__t2 IN_P|SNS2__t1 VDD__t5 pfet L=1U W=9U AS=3.6P AD=3.6P
+ PS=18.8U PD=18.8U
* device instance $14 r0 *1 57,75 pfet
M$14 VDD__t6 FB|OUT__t3 IN_P|SNS2__t2 VDD__t7 pfet L=1U W=1U AS=0.4P AD=0.4P
+ PS=2.8U PD=2.8U
* device instance $15 r0 *1 110,75 pfet
M$15 VDD__t8 FB|OUT__t4 VREF__t0 VDD__t9 pfet L=1U W=8U AS=3.2P AD=3.2P
+ PS=16.8U PD=16.8U
* device instance $16 r0 *1 122,75 pfet
M$16 VDD__t13 FB|OUT__t6 VREF__t3 VDD__t11 pfet L=1U W=1U AS=0.4P AD=0.4P
+ PS=2.8U PD=2.8U
* device instance $17 r0 *1 134,75 pfet
M$17 VDD__t12 FB|OUT__t5 VREF__t2 VDD__t10 pfet L=1U W=1U AS=0.4P AD=0.4P
+ PS=2.8U PD=2.8U
* device instance $18 r0 *1 141,54.715 rppd
X$18 T001|T003|T007|T015|T031|T063|T127|TN0__t0
+ T001|T003|T007|T015|T031|T063|T127|TN0__t1 VSS__t6 rppd r=479.566301097
+ L=3.43U W=2U
* device instance $19 r0 *1 143.7,54.715 rppd
X$19 T030__t1 T029__t0 VSS__t7 rppd r=479.566301097 L=3.43U W=2U
* device instance $20 r0 *1 146.4,54.715 rppd
X$20 T030__t0 T001|T003|T007|T015|T031|T063|T127|TN0__t5 VSS__t8 rppd
+ r=479.566301097 L=3.43U W=2U
* device instance $21 r0 *1 149.1,54.715 rppd
X$21 T060__t1 T059__t0 VSS__t9 rppd r=479.566301097 L=3.43U W=2U
* device instance $22 r0 *1 151.8,54.715 rppd
X$22 T060__t0 T061__t0 VSS__t10 rppd r=479.566301097 L=3.43U W=2U
* device instance $23 r0 *1 154.5,54.715 rppd
X$23 T090__t1 T089__t0 VSS__t11 rppd r=479.566301097 L=3.43U W=2U
* device instance $24 r0 *1 157.2,54.715 rppd
X$24 T090__t0 T091__t0 VSS__t12 rppd r=479.566301097 L=3.43U W=2U
* device instance $25 r0 *1 159.9,54.715 rppd
X$25 T120__t1 T119__t0 VSS__t13 rppd r=479.566301097 L=3.43U W=2U
* device instance $26 r0 *1 162.6,54.715 rppd
X$26 T120__t0 T121__t0 VSS__t14 rppd r=479.566301097 L=3.43U W=2U
* device instance $27 r0 *1 165.3,54.715 rppd
X$27 T150__t1 T149__t0 VSS__t15 rppd r=479.566301097 L=3.43U W=2U
* device instance $28 r0 *1 168,54.715 rppd
X$28 T150__t0 T151__t0 VSS__t16 rppd r=479.566301097 L=3.43U W=2U
* device instance $29 r0 *1 170.7,54.715 rppd
X$29 T180__t1 T179__t0 VSS__t17 rppd r=479.566301097 L=3.43U W=2U
* device instance $30 r0 *1 173.4,54.715 rppd
X$30 T180__t0 T181__t0 VSS__t18 rppd r=479.566301097 L=3.43U W=2U
* device instance $31 r0 *1 176.1,54.715 rppd
X$31 T210__t1 T209__t0 VSS__t19 rppd r=479.566301097 L=3.43U W=2U
* device instance $32 r0 *1 178.8,54.715 rppd
X$32 T210__t0 T211__t0 VSS__t20 rppd r=479.566301097 L=3.43U W=2U
* device instance $33 r0 *1 181.5,54.715 rppd
X$33 T240__t0 T239__t0 VSS__t21 rppd r=479.566301097 L=3.43U W=2U
* device instance $34 r0 *1 184.2,54.715 rppd
X$34 T240__t1 T241__t0 VSS__t22 rppd r=479.566301097 L=3.43U W=2U
* device instance $35 r0 *1 141,59.345 rppd
X$35 T001|T003|T007|T015|T031|T063|T127|TN0__t12 T002__t0 VSS__t23 rppd
+ r=479.566301097 L=3.43U W=2U
* device instance $36 r0 *1 143.7,59.345 rppd
X$36 T029__t1 T028__t0 VSS__t24 rppd r=479.566301097 L=3.43U W=2U
* device instance $37 r0 *1 146.4,59.345 rppd
X$37 T001|T003|T007|T015|T031|T063|T127|TN0__t10 T032__t0 VSS__t25 rppd
+ r=479.566301097 L=3.43U W=2U
* device instance $38 r0 *1 149.1,59.345 rppd
X$38 T059__t1 T058__t0 VSS__t26 rppd r=479.566301097 L=3.43U W=2U
* device instance $39 r0 *1 151.8,59.345 rppd
X$39 T061__t1 T062__t0 VSS__t27 rppd r=479.566301097 L=3.43U W=2U
* device instance $40 r0 *1 154.5,59.345 rppd
X$40 T089__t1 T088__t0 VSS__t28 rppd r=479.566301097 L=3.43U W=2U
* device instance $41 r0 *1 157.2,59.345 rppd
X$41 T091__t1 T092__t0 VSS__t29 rppd r=479.566301097 L=3.43U W=2U
* device instance $42 r0 *1 159.9,59.345 rppd
X$42 T119__t1 T118__t0 VSS__t30 rppd r=479.566301097 L=3.43U W=2U
* device instance $43 r0 *1 162.6,59.345 rppd
X$43 T121__t1 T122__t0 VSS__t31 rppd r=479.566301097 L=3.43U W=2U
* device instance $44 r0 *1 165.3,59.345 rppd
X$44 T149__t1 T148__t0 VSS__t32 rppd r=479.566301097 L=3.43U W=2U
* device instance $45 r0 *1 168,59.345 rppd
X$45 T151__t1 T152__t0 VSS__t33 rppd r=479.566301097 L=3.43U W=2U
* device instance $46 r0 *1 170.7,59.345 rppd
X$46 T179__t1 T178__t0 VSS__t34 rppd r=479.566301097 L=3.43U W=2U
* device instance $47 r0 *1 173.4,59.345 rppd
X$47 T181__t1 T182__t0 VSS__t35 rppd r=479.566301097 L=3.43U W=2U
* device instance $48 r0 *1 176.1,59.345 rppd
X$48 T209__t1 T208__t0 VSS__t36 rppd r=479.566301097 L=3.43U W=2U
* device instance $49 r0 *1 178.8,59.345 rppd
X$49 T211__t1 T212__t0 VSS__t37 rppd r=479.566301097 L=3.43U W=2U
* device instance $50 r0 *1 181.5,59.345 rppd
X$50 T239__t1 T238__t0 VSS__t38 rppd r=479.566301097 L=3.43U W=2U
* device instance $51 r0 *1 184.2,59.345 rppd
X$51 T241__t1 T242__t0 VSS__t39 rppd r=479.566301097 L=3.43U W=2U
* device instance $52 r0 *1 141,63.975 rppd
X$52 T002__t1 T001|T003|T007|T015|T031|T063|T127|TN0__t7 VSS__t40 rppd
+ r=479.566301097 L=3.43U W=2U
* device instance $53 r0 *1 143.7,63.975 rppd
X$53 T028__t1 T027__t0 VSS__t41 rppd r=479.566301097 L=3.43U W=2U
* device instance $54 r0 *1 146.4,63.975 rppd
X$54 T032__t1 T033__t0 VSS__t42 rppd r=479.566301097 L=3.43U W=2U
* device instance $55 r0 *1 149.1,63.975 rppd
X$55 T058__t1 T057__t0 VSS__t43 rppd r=479.566301097 L=3.43U W=2U
* device instance $56 r0 *1 151.8,63.975 rppd
X$56 T062__t1 T001|T003|T007|T015|T031|T063|T127|TN0__t8 VSS__t44 rppd
+ r=479.566301097 L=3.43U W=2U
* device instance $57 r0 *1 154.5,63.975 rppd
X$57 T088__t1 T087__t0 VSS__t45 rppd r=479.566301097 L=3.43U W=2U
* device instance $58 r0 *1 157.2,63.975 rppd
X$58 T092__t1 T093__t0 VSS__t46 rppd r=479.566301097 L=3.43U W=2U
* device instance $59 r0 *1 159.9,63.975 rppd
X$59 T118__t1 T117__t0 VSS__t47 rppd r=479.566301097 L=3.43U W=2U
* device instance $60 r0 *1 162.6,63.975 rppd
X$60 T122__t1 T123__t0 VSS__t48 rppd r=479.566301097 L=3.43U W=2U
* device instance $61 r0 *1 165.3,63.975 rppd
X$61 T148__t1 T147__t0 VSS__t49 rppd r=479.566301097 L=3.43U W=2U
* device instance $62 r0 *1 168,63.975 rppd
X$62 T152__t1 T153__t0 VSS__t50 rppd r=479.566301097 L=3.43U W=2U
* device instance $63 r0 *1 170.7,63.975 rppd
X$63 T178__t1 T177__t0 VSS__t51 rppd r=479.566301097 L=3.43U W=2U
* device instance $64 r0 *1 173.4,63.975 rppd
X$64 T182__t1 T183__t0 VSS__t52 rppd r=479.566301097 L=3.43U W=2U
* device instance $65 r0 *1 176.1,63.975 rppd
X$65 T208__t1 T207__t0 VSS__t53 rppd r=479.566301097 L=3.43U W=2U
* device instance $66 r0 *1 178.8,63.975 rppd
X$66 T212__t1 T213__t0 VSS__t54 rppd r=479.566301097 L=3.43U W=2U
* device instance $67 r0 *1 181.5,63.975 rppd
X$67 T238__t1 T237__t0 VSS__t55 rppd r=479.566301097 L=3.43U W=2U
* device instance $68 r0 *1 184.2,63.975 rppd
X$68 T242__t1 T243__t0 VSS__t56 rppd r=479.566301097 L=3.43U W=2U
* device instance $69 r0 *1 141,68.605 rppd
X$69 T001|T003|T007|T015|T031|T063|T127|TN0__t13 T004__t0 VSS__t57 rppd
+ r=479.566301097 L=3.43U W=2U
* device instance $70 r0 *1 143.7,68.605 rppd
X$70 T027__t1 T026__t0 VSS__t58 rppd r=479.566301097 L=3.43U W=2U
* device instance $71 r0 *1 146.4,68.605 rppd
X$71 T033__t1 T034__t0 VSS__t59 rppd r=479.566301097 L=3.43U W=2U
* device instance $72 r0 *1 149.1,68.605 rppd
X$72 T057__t1 T056__t0 VSS__t60 rppd r=479.566301097 L=3.43U W=2U
* device instance $73 r0 *1 151.8,68.605 rppd
X$73 T001|T003|T007|T015|T031|T063|T127|TN0__t11 T064__t0 VSS__t61 rppd
+ r=479.566301097 L=3.43U W=2U
* device instance $74 r0 *1 154.5,68.605 rppd
X$74 T087__t1 T086__t0 VSS__t62 rppd r=479.566301097 L=3.43U W=2U
* device instance $75 r0 *1 157.2,68.605 rppd
X$75 T093__t1 T094__t0 VSS__t63 rppd r=479.566301097 L=3.43U W=2U
* device instance $76 r0 *1 159.9,68.605 rppd
X$76 T117__t1 T116__t0 VSS__t64 rppd r=479.566301097 L=3.43U W=2U
* device instance $77 r0 *1 162.6,68.605 rppd
X$77 T123__t1 T124__t0 VSS__t65 rppd r=479.566301097 L=3.43U W=2U
* device instance $78 r0 *1 165.3,68.605 rppd
X$78 T147__t1 T146__t0 VSS__t66 rppd r=479.566301097 L=3.43U W=2U
* device instance $79 r0 *1 168,68.605 rppd
X$79 T153__t1 T154__t0 VSS__t67 rppd r=479.566301097 L=3.43U W=2U
* device instance $80 r0 *1 170.7,68.605 rppd
X$80 T177__t1 T176__t0 VSS__t68 rppd r=479.566301097 L=3.43U W=2U
* device instance $81 r0 *1 173.4,68.605 rppd
X$81 T183__t1 T184__t0 VSS__t69 rppd r=479.566301097 L=3.43U W=2U
* device instance $82 r0 *1 176.1,68.605 rppd
X$82 T207__t1 T206__t0 VSS__t70 rppd r=479.566301097 L=3.43U W=2U
* device instance $83 r0 *1 178.8,68.605 rppd
X$83 T213__t1 T214__t0 VSS__t71 rppd r=479.566301097 L=3.43U W=2U
* device instance $84 r0 *1 181.5,68.605 rppd
X$84 T237__t1 T236__t0 VSS__t72 rppd r=479.566301097 L=3.43U W=2U
* device instance $85 r0 *1 184.2,68.605 rppd
X$85 T243__t1 T244__t0 VSS__t73 rppd r=479.566301097 L=3.43U W=2U
* device instance $86 r0 *1 141,73.235 rppd
X$86 T004__t1 T005__t0 VSS__t74 rppd r=479.566301097 L=3.43U W=2U
* device instance $87 r0 *1 143.7,73.235 rppd
X$87 T026__t1 T025__t0 VSS__t75 rppd r=479.566301097 L=3.43U W=2U
* device instance $88 r0 *1 146.4,73.235 rppd
X$88 T034__t1 T035__t0 VSS__t76 rppd r=479.566301097 L=3.43U W=2U
* device instance $89 r0 *1 149.1,73.235 rppd
X$89 T056__t1 T055__t0 VSS__t77 rppd r=479.566301097 L=3.43U W=2U
* device instance $90 r0 *1 151.8,73.235 rppd
X$90 T064__t1 T065__t0 VSS__t78 rppd r=479.566301097 L=3.43U W=2U
* device instance $91 r0 *1 154.5,73.235 rppd
X$91 T086__t1 T085__t0 VSS__t79 rppd r=479.566301097 L=3.43U W=2U
* device instance $92 r0 *1 157.2,73.235 rppd
X$92 T094__t1 T095__t0 VSS__t80 rppd r=479.566301097 L=3.43U W=2U
* device instance $93 r0 *1 159.9,73.235 rppd
X$93 T116__t1 T115__t0 VSS__t81 rppd r=479.566301097 L=3.43U W=2U
* device instance $94 r0 *1 162.6,73.235 rppd
X$94 T124__t1 T125__t0 VSS__t82 rppd r=479.566301097 L=3.43U W=2U
* device instance $95 r0 *1 165.3,73.235 rppd
X$95 T146__t1 T145__t0 VSS__t83 rppd r=479.566301097 L=3.43U W=2U
* device instance $96 r0 *1 168,73.235 rppd
X$96 T154__t1 T155__t0 VSS__t84 rppd r=479.566301097 L=3.43U W=2U
* device instance $97 r0 *1 170.7,73.235 rppd
X$97 T176__t1 T175__t0 VSS__t85 rppd r=479.566301097 L=3.43U W=2U
* device instance $98 r0 *1 173.4,73.235 rppd
X$98 T184__t1 T185__t0 VSS__t86 rppd r=479.566301097 L=3.43U W=2U
* device instance $99 r0 *1 176.1,73.235 rppd
X$99 T206__t1 T205__t0 VSS__t87 rppd r=479.566301097 L=3.43U W=2U
* device instance $100 r0 *1 178.8,73.235 rppd
X$100 T214__t1 T215__t0 VSS__t88 rppd r=479.566301097 L=3.43U W=2U
* device instance $101 r0 *1 181.5,73.235 rppd
X$101 T236__t1 T235__t0 VSS__t89 rppd r=479.566301097 L=3.43U W=2U
* device instance $102 r0 *1 184.2,73.235 rppd
X$102 T244__t1 T245__t0 VSS__t90 rppd r=479.566301097 L=3.43U W=2U
* device instance $103 r0 *1 141,77.865 rppd
X$103 T005__t1 T006__t0 VSS__t91 rppd r=479.566301097 L=3.43U W=2U
* device instance $104 r0 *1 143.7,77.865 rppd
X$104 T025__t1 T024__t0 VSS__t92 rppd r=479.566301097 L=3.43U W=2U
* device instance $105 r0 *1 146.4,77.865 rppd
X$105 T035__t1 T036__t0 VSS__t93 rppd r=479.566301097 L=3.43U W=2U
* device instance $106 r0 *1 149.1,77.865 rppd
X$106 T055__t1 T054__t0 VSS__t94 rppd r=479.566301097 L=3.43U W=2U
* device instance $107 r0 *1 151.8,77.865 rppd
X$107 T065__t1 T066__t0 VSS__t95 rppd r=479.566301097 L=3.43U W=2U
* device instance $108 r0 *1 154.5,77.865 rppd
X$108 T085__t1 T084__t0 VSS__t96 rppd r=479.566301097 L=3.43U W=2U
* device instance $109 r0 *1 157.2,77.865 rppd
X$109 T095__t1 T096__t0 VSS__t97 rppd r=479.566301097 L=3.43U W=2U
* device instance $110 r0 *1 159.9,77.865 rppd
X$110 T115__t1 T114__t0 VSS__t98 rppd r=479.566301097 L=3.43U W=2U
* device instance $111 r0 *1 162.6,77.865 rppd
X$111 T125__t1 T126__t0 VSS__t99 rppd r=479.566301097 L=3.43U W=2U
* device instance $112 r0 *1 165.3,77.865 rppd
X$112 T145__t1 T144__t0 VSS__t100 rppd r=479.566301097 L=3.43U W=2U
* device instance $113 r0 *1 168,77.865 rppd
X$113 T155__t1 T156__t0 VSS__t101 rppd r=479.566301097 L=3.43U W=2U
* device instance $114 r0 *1 170.7,77.865 rppd
X$114 T175__t1 T174__t0 VSS__t102 rppd r=479.566301097 L=3.43U W=2U
* device instance $115 r0 *1 173.4,77.865 rppd
X$115 T185__t1 T186__t0 VSS__t103 rppd r=479.566301097 L=3.43U W=2U
* device instance $116 r0 *1 176.1,77.865 rppd
X$116 T205__t1 T204__t0 VSS__t104 rppd r=479.566301097 L=3.43U W=2U
* device instance $117 r0 *1 178.8,77.865 rppd
X$117 T215__t1 T216__t0 VSS__t105 rppd r=479.566301097 L=3.43U W=2U
* device instance $118 r0 *1 181.5,77.865 rppd
X$118 T235__t1 T234__t0 VSS__t106 rppd r=479.566301097 L=3.43U W=2U
* device instance $119 r0 *1 184.2,77.865 rppd
X$119 T245__t1 T246__t0 VSS__t107 rppd r=479.566301097 L=3.43U W=2U
* device instance $120 r0 *1 141,82.495 rppd
X$120 T006__t1 T001|T003|T007|T015|T031|T063|T127|TN0__t9 VSS__t108 rppd
+ r=479.566301097 L=3.43U W=2U
* device instance $121 r0 *1 143.7,82.495 rppd
X$121 T024__t1 T023__t0 VSS__t109 rppd r=479.566301097 L=3.43U W=2U
* device instance $122 r0 *1 146.4,82.495 rppd
X$122 T036__t1 T037__t0 VSS__t110 rppd r=479.566301097 L=3.43U W=2U
* device instance $123 r0 *1 149.1,82.495 rppd
X$123 T054__t1 T053__t0 VSS__t111 rppd r=479.566301097 L=3.43U W=2U
* device instance $124 r0 *1 151.8,82.495 rppd
X$124 T066__t1 T067__t0 VSS__t112 rppd r=479.566301097 L=3.43U W=2U
* device instance $125 r0 *1 154.5,82.495 rppd
X$125 T084__t1 T083__t0 VSS__t113 rppd r=479.566301097 L=3.43U W=2U
* device instance $126 r0 *1 157.2,82.495 rppd
X$126 T096__t1 T097__t0 VSS__t114 rppd r=479.566301097 L=3.43U W=2U
* device instance $127 r0 *1 159.9,82.495 rppd
X$127 T114__t1 T113__t0 VSS__t115 rppd r=479.566301097 L=3.43U W=2U
* device instance $128 r0 *1 162.6,82.495 rppd
X$128 T126__t1 T001|T003|T007|T015|T031|T063|T127|TN0__t6 VSS__t116 rppd
+ r=479.566301097 L=3.43U W=2U
* device instance $129 r0 *1 165.3,82.495 rppd
X$129 T144__t1 T143__t0 VSS__t117 rppd r=479.566301097 L=3.43U W=2U
* device instance $130 r0 *1 168,82.495 rppd
X$130 T156__t1 T157__t0 VSS__t118 rppd r=479.566301097 L=3.43U W=2U
* device instance $131 r0 *1 170.7,82.495 rppd
X$131 T174__t1 T173__t0 VSS__t119 rppd r=479.566301097 L=3.43U W=2U
* device instance $132 r0 *1 173.4,82.495 rppd
X$132 T186__t1 T187__t0 VSS__t120 rppd r=479.566301097 L=3.43U W=2U
* device instance $133 r0 *1 176.1,82.495 rppd
X$133 T204__t1 T203__t0 VSS__t121 rppd r=479.566301097 L=3.43U W=2U
* device instance $134 r0 *1 178.8,82.495 rppd
X$134 T216__t1 T217__t0 VSS__t122 rppd r=479.566301097 L=3.43U W=2U
* device instance $135 r0 *1 181.5,82.495 rppd
X$135 T234__t1 T233__t0 VSS__t123 rppd r=479.566301097 L=3.43U W=2U
* device instance $136 r0 *1 184.2,82.495 rppd
X$136 T246__t1 T247__t0 VSS__t124 rppd r=479.566301097 L=3.43U W=2U
* device instance $137 r0 *1 141,87.125 rppd
X$137 T001|T003|T007|T015|T031|T063|T127|TN0__t14 T008__t0 VSS__t125 rppd
+ r=479.566301097 L=3.43U W=2U
* device instance $138 r0 *1 143.7,87.125 rppd
X$138 T023__t1 T022__t0 VSS__t126 rppd r=479.566301097 L=3.43U W=2U
* device instance $139 r0 *1 146.4,87.125 rppd
X$139 T037__t1 T038__t0 VSS__t127 rppd r=479.566301097 L=3.43U W=2U
* device instance $140 r0 *1 149.1,87.125 rppd
X$140 T053__t1 T052__t0 VSS__t128 rppd r=479.566301097 L=3.43U W=2U
* device instance $141 r0 *1 151.8,87.125 rppd
X$141 T067__t1 T068__t0 VSS__t129 rppd r=479.566301097 L=3.43U W=2U
* device instance $142 r0 *1 154.5,87.125 rppd
X$142 T083__t1 T082__t0 VSS__t130 rppd r=479.566301097 L=3.43U W=2U
* device instance $143 r0 *1 157.2,87.125 rppd
X$143 T097__t1 T098__t0 VSS__t131 rppd r=479.566301097 L=3.43U W=2U
* device instance $144 r0 *1 159.9,87.125 rppd
X$144 T113__t1 T112__t0 VSS__t132 rppd r=479.566301097 L=3.43U W=2U
* device instance $145 r0 *1 162.6,87.125 rppd
X$145 T001|T003|T007|T015|T031|T063|T127|TN0__t15 T128__t0 VSS__t133 rppd
+ r=479.566301097 L=3.43U W=2U
* device instance $146 r0 *1 165.3,87.125 rppd
X$146 T143__t1 T142__t0 VSS__t134 rppd r=479.566301097 L=3.43U W=2U
* device instance $147 r0 *1 168,87.125 rppd
X$147 T157__t1 T158__t0 VSS__t135 rppd r=479.566301097 L=3.43U W=2U
* device instance $148 r0 *1 170.7,87.125 rppd
X$148 T173__t1 T172__t0 VSS__t136 rppd r=479.566301097 L=3.43U W=2U
* device instance $149 r0 *1 173.4,87.125 rppd
X$149 T187__t1 T188__t0 VSS__t137 rppd r=479.566301097 L=3.43U W=2U
* device instance $150 r0 *1 176.1,87.125 rppd
X$150 T203__t1 T202__t0 VSS__t138 rppd r=479.566301097 L=3.43U W=2U
* device instance $151 r0 *1 178.8,87.125 rppd
X$151 T217__t1 T218__t0 VSS__t139 rppd r=479.566301097 L=3.43U W=2U
* device instance $152 r0 *1 181.5,87.125 rppd
X$152 T233__t1 T232__t0 VSS__t140 rppd r=479.566301097 L=3.43U W=2U
* device instance $153 r0 *1 184.2,87.125 rppd
X$153 T247__t1 T248__t0 VSS__t141 rppd r=479.566301097 L=3.43U W=2U
* device instance $154 r0 *1 49,93.725 rppd
X$154 IN_P|SNS2__t3 CB2__t0 VSS__t261 rppd r=10753.8434696 L=82.7U W=2U
* device instance $155 r0 *1 109.8,90.56 rppd
X$155 VREF__t1 T001|T003|T007|T015|T031|T063|T127|TN0__t2 VSS__t262 rppd
+ r=4856.53539382 L=37.2U W=2U
* device instance $156 r0 *1 141,91.755 rppd
X$156 T008__t1 T009__t0 VSS__t142 rppd r=479.566301097 L=3.43U W=2U
* device instance $157 r0 *1 143.7,91.755 rppd
X$157 T022__t1 T021__t0 VSS__t143 rppd r=479.566301097 L=3.43U W=2U
* device instance $158 r0 *1 146.4,91.755 rppd
X$158 T038__t1 T039__t0 VSS__t144 rppd r=479.566301097 L=3.43U W=2U
* device instance $159 r0 *1 149.1,91.755 rppd
X$159 T052__t1 T051__t0 VSS__t145 rppd r=479.566301097 L=3.43U W=2U
* device instance $160 r0 *1 151.8,91.755 rppd
X$160 T068__t1 T069__t0 VSS__t146 rppd r=479.566301097 L=3.43U W=2U
* device instance $161 r0 *1 154.5,91.755 rppd
X$161 T082__t1 T081__t0 VSS__t147 rppd r=479.566301097 L=3.43U W=2U
* device instance $162 r0 *1 157.2,91.755 rppd
X$162 T098__t1 T099__t0 VSS__t148 rppd r=479.566301097 L=3.43U W=2U
* device instance $163 r0 *1 159.9,91.755 rppd
X$163 T112__t1 T111__t0 VSS__t149 rppd r=479.566301097 L=3.43U W=2U
* device instance $164 r0 *1 162.6,91.755 rppd
X$164 T128__t1 T129__t0 VSS__t150 rppd r=479.566301097 L=3.43U W=2U
* device instance $165 r0 *1 165.3,91.755 rppd
X$165 T142__t1 T141__t0 VSS__t151 rppd r=479.566301097 L=3.43U W=2U
* device instance $166 r0 *1 168,91.755 rppd
X$166 T158__t1 T159__t0 VSS__t152 rppd r=479.566301097 L=3.43U W=2U
* device instance $167 r0 *1 170.7,91.755 rppd
X$167 T172__t1 T171__t0 VSS__t153 rppd r=479.566301097 L=3.43U W=2U
* device instance $168 r0 *1 173.4,91.755 rppd
X$168 T188__t1 T189__t0 VSS__t154 rppd r=479.566301097 L=3.43U W=2U
* device instance $169 r0 *1 176.1,91.755 rppd
X$169 T202__t1 T201__t0 VSS__t155 rppd r=479.566301097 L=3.43U W=2U
* device instance $170 r0 *1 178.8,91.755 rppd
X$170 T218__t1 T219__t0 VSS__t156 rppd r=479.566301097 L=3.43U W=2U
* device instance $171 r0 *1 181.5,91.755 rppd
X$171 T232__t1 T231__t0 VSS__t157 rppd r=479.566301097 L=3.43U W=2U
* device instance $172 r0 *1 184.2,91.755 rppd
X$172 T248__t1 T249__t0 VSS__t158 rppd r=479.566301097 L=3.43U W=2U
* device instance $173 r0 *1 141,96.385 rppd
X$173 T009__t1 T010__t0 VSS__t159 rppd r=479.566301097 L=3.43U W=2U
* device instance $174 r0 *1 143.7,96.385 rppd
X$174 T021__t1 T020__t0 VSS__t160 rppd r=479.566301097 L=3.43U W=2U
* device instance $175 r0 *1 146.4,96.385 rppd
X$175 T039__t1 T040__t0 VSS__t161 rppd r=479.566301097 L=3.43U W=2U
* device instance $176 r0 *1 149.1,96.385 rppd
X$176 T051__t1 T050__t0 VSS__t162 rppd r=479.566301097 L=3.43U W=2U
* device instance $177 r0 *1 151.8,96.385 rppd
X$177 T069__t1 T070__t0 VSS__t163 rppd r=479.566301097 L=3.43U W=2U
* device instance $178 r0 *1 154.5,96.385 rppd
X$178 T081__t1 T080__t0 VSS__t164 rppd r=479.566301097 L=3.43U W=2U
* device instance $179 r0 *1 157.2,96.385 rppd
X$179 T099__t1 T100__t0 VSS__t165 rppd r=479.566301097 L=3.43U W=2U
* device instance $180 r0 *1 159.9,96.385 rppd
X$180 T111__t1 T110__t0 VSS__t166 rppd r=479.566301097 L=3.43U W=2U
* device instance $181 r0 *1 162.6,96.385 rppd
X$181 T129__t1 T130__t0 VSS__t167 rppd r=479.566301097 L=3.43U W=2U
* device instance $182 r0 *1 165.3,96.385 rppd
X$182 T141__t1 T140__t0 VSS__t168 rppd r=479.566301097 L=3.43U W=2U
* device instance $183 r0 *1 168,96.385 rppd
X$183 T159__t1 T160__t0 VSS__t169 rppd r=479.566301097 L=3.43U W=2U
* device instance $184 r0 *1 170.7,96.385 rppd
X$184 T171__t1 T170__t0 VSS__t170 rppd r=479.566301097 L=3.43U W=2U
* device instance $185 r0 *1 173.4,96.385 rppd
X$185 T189__t1 T190__t0 VSS__t171 rppd r=479.566301097 L=3.43U W=2U
* device instance $186 r0 *1 176.1,96.385 rppd
X$186 T201__t1 T200__t0 VSS__t172 rppd r=479.566301097 L=3.43U W=2U
* device instance $187 r0 *1 178.8,96.385 rppd
X$187 T219__t1 T220__t0 VSS__t173 rppd r=479.566301097 L=3.43U W=2U
* device instance $188 r0 *1 181.5,96.385 rppd
X$188 T231__t1 T230__t0 VSS__t174 rppd r=479.566301097 L=3.43U W=2U
* device instance $189 r0 *1 184.2,96.385 rppd
X$189 T249__t1 T250__t0 VSS__t175 rppd r=479.566301097 L=3.43U W=2U
* device instance $190 r0 *1 141,101.015 rppd
X$190 T010__t1 T011__t0 VSS__t176 rppd r=479.566301097 L=3.43U W=2U
* device instance $191 r0 *1 143.7,101.015 rppd
X$191 T020__t1 T019__t0 VSS__t177 rppd r=479.566301097 L=3.43U W=2U
* device instance $192 r0 *1 146.4,101.015 rppd
X$192 T040__t1 T041__t0 VSS__t178 rppd r=479.566301097 L=3.43U W=2U
* device instance $193 r0 *1 149.1,101.015 rppd
X$193 T050__t1 T049__t0 VSS__t179 rppd r=479.566301097 L=3.43U W=2U
* device instance $194 r0 *1 151.8,101.015 rppd
X$194 T070__t1 T071__t0 VSS__t180 rppd r=479.566301097 L=3.43U W=2U
* device instance $195 r0 *1 154.5,101.015 rppd
X$195 T080__t1 T079__t0 VSS__t181 rppd r=479.566301097 L=3.43U W=2U
* device instance $196 r0 *1 157.2,101.015 rppd
X$196 T100__t1 T101__t0 VSS__t182 rppd r=479.566301097 L=3.43U W=2U
* device instance $197 r0 *1 159.9,101.015 rppd
X$197 T110__t1 T109__t0 VSS__t183 rppd r=479.566301097 L=3.43U W=2U
* device instance $198 r0 *1 162.6,101.015 rppd
X$198 T130__t1 T131__t0 VSS__t184 rppd r=479.566301097 L=3.43U W=2U
* device instance $199 r0 *1 165.3,101.015 rppd
X$199 T140__t1 T139__t0 VSS__t185 rppd r=479.566301097 L=3.43U W=2U
* device instance $200 r0 *1 168,101.015 rppd
X$200 T160__t1 T161__t0 VSS__t186 rppd r=479.566301097 L=3.43U W=2U
* device instance $201 r0 *1 170.7,101.015 rppd
X$201 T170__t1 T169__t0 VSS__t187 rppd r=479.566301097 L=3.43U W=2U
* device instance $202 r0 *1 173.4,101.015 rppd
X$202 T190__t1 T191__t0 VSS__t188 rppd r=479.566301097 L=3.43U W=2U
* device instance $203 r0 *1 176.1,101.015 rppd
X$203 T200__t1 T199__t0 VSS__t189 rppd r=479.566301097 L=3.43U W=2U
* device instance $204 r0 *1 178.8,101.015 rppd
X$204 T220__t1 T221__t0 VSS__t190 rppd r=479.566301097 L=3.43U W=2U
* device instance $205 r0 *1 181.5,101.015 rppd
X$205 T230__t1 T229__t0 VSS__t191 rppd r=479.566301097 L=3.43U W=2U
* device instance $206 r0 *1 184.2,101.015 rppd
X$206 T250__t1 T251__t0 VSS__t192 rppd r=479.566301097 L=3.43U W=2U
* device instance $207 r0 *1 141,105.645 rppd
X$207 T011__t1 T012__t0 VSS__t193 rppd r=479.566301097 L=3.43U W=2U
* device instance $208 r0 *1 143.7,105.645 rppd
X$208 T019__t1 T018__t0 VSS__t194 rppd r=479.566301097 L=3.43U W=2U
* device instance $209 r0 *1 146.4,105.645 rppd
X$209 T041__t1 T042__t0 VSS__t195 rppd r=479.566301097 L=3.43U W=2U
* device instance $210 r0 *1 149.1,105.645 rppd
X$210 T049__t1 T048__t0 VSS__t196 rppd r=479.566301097 L=3.43U W=2U
* device instance $211 r0 *1 151.8,105.645 rppd
X$211 T071__t1 T072__t0 VSS__t197 rppd r=479.566301097 L=3.43U W=2U
* device instance $212 r0 *1 154.5,105.645 rppd
X$212 T079__t1 T078__t0 VSS__t198 rppd r=479.566301097 L=3.43U W=2U
* device instance $213 r0 *1 157.2,105.645 rppd
X$213 T101__t1 T102__t0 VSS__t199 rppd r=479.566301097 L=3.43U W=2U
* device instance $214 r0 *1 159.9,105.645 rppd
X$214 T109__t1 T108__t0 VSS__t200 rppd r=479.566301097 L=3.43U W=2U
* device instance $215 r0 *1 162.6,105.645 rppd
X$215 T131__t1 T132__t0 VSS__t201 rppd r=479.566301097 L=3.43U W=2U
* device instance $216 r0 *1 165.3,105.645 rppd
X$216 T139__t1 T138__t0 VSS__t202 rppd r=479.566301097 L=3.43U W=2U
* device instance $217 r0 *1 168,105.645 rppd
X$217 T161__t1 T162__t0 VSS__t203 rppd r=479.566301097 L=3.43U W=2U
* device instance $218 r0 *1 170.7,105.645 rppd
X$218 T169__t1 T168__t0 VSS__t204 rppd r=479.566301097 L=3.43U W=2U
* device instance $219 r0 *1 173.4,105.645 rppd
X$219 T191__t1 T192__t0 VSS__t205 rppd r=479.566301097 L=3.43U W=2U
* device instance $220 r0 *1 176.1,105.645 rppd
X$220 T199__t1 T198__t0 VSS__t206 rppd r=479.566301097 L=3.43U W=2U
* device instance $221 r0 *1 178.8,105.645 rppd
X$221 T221__t1 T222__t0 VSS__t207 rppd r=479.566301097 L=3.43U W=2U
* device instance $222 r0 *1 181.5,105.645 rppd
X$222 T229__t1 T228__t0 VSS__t208 rppd r=479.566301097 L=3.43U W=2U
* device instance $223 r0 *1 184.2,105.645 rppd
X$223 T251__t1 T252__t0 VSS__t209 rppd r=479.566301097 L=3.43U W=2U
* device instance $224 r0 *1 141,110.275 rppd
X$224 T012__t1 T013__t0 VSS__t210 rppd r=479.566301097 L=3.43U W=2U
* device instance $225 r0 *1 143.7,110.275 rppd
X$225 T018__t1 T017__t0 VSS__t211 rppd r=479.566301097 L=3.43U W=2U
* device instance $226 r0 *1 146.4,110.275 rppd
X$226 T042__t1 T043__t0 VSS__t212 rppd r=479.566301097 L=3.43U W=2U
* device instance $227 r0 *1 149.1,110.275 rppd
X$227 T048__t1 T047__t0 VSS__t213 rppd r=479.566301097 L=3.43U W=2U
* device instance $228 r0 *1 151.8,110.275 rppd
X$228 T072__t1 T073__t0 VSS__t214 rppd r=479.566301097 L=3.43U W=2U
* device instance $229 r0 *1 154.5,110.275 rppd
X$229 T078__t1 T077__t0 VSS__t215 rppd r=479.566301097 L=3.43U W=2U
* device instance $230 r0 *1 157.2,110.275 rppd
X$230 T102__t1 T103__t0 VSS__t216 rppd r=479.566301097 L=3.43U W=2U
* device instance $231 r0 *1 159.9,110.275 rppd
X$231 T108__t1 T107__t0 VSS__t217 rppd r=479.566301097 L=3.43U W=2U
* device instance $232 r0 *1 162.6,110.275 rppd
X$232 T132__t1 T133__t0 VSS__t218 rppd r=479.566301097 L=3.43U W=2U
* device instance $233 r0 *1 165.3,110.275 rppd
X$233 T138__t1 T137__t0 VSS__t219 rppd r=479.566301097 L=3.43U W=2U
* device instance $234 r0 *1 168,110.275 rppd
X$234 T162__t1 T163__t0 VSS__t220 rppd r=479.566301097 L=3.43U W=2U
* device instance $235 r0 *1 170.7,110.275 rppd
X$235 T168__t1 T167__t0 VSS__t221 rppd r=479.566301097 L=3.43U W=2U
* device instance $236 r0 *1 173.4,110.275 rppd
X$236 T192__t1 T193__t0 VSS__t222 rppd r=479.566301097 L=3.43U W=2U
* device instance $237 r0 *1 176.1,110.275 rppd
X$237 T198__t1 T197__t0 VSS__t223 rppd r=479.566301097 L=3.43U W=2U
* device instance $238 r0 *1 178.8,110.275 rppd
X$238 T222__t1 T223__t0 VSS__t224 rppd r=479.566301097 L=3.43U W=2U
* device instance $239 r0 *1 181.5,110.275 rppd
X$239 T228__t1 T227__t0 VSS__t225 rppd r=479.566301097 L=3.43U W=2U
* device instance $240 r0 *1 184.2,110.275 rppd
X$240 T252__t1 T253__t0 VSS__t226 rppd r=479.566301097 L=3.43U W=2U
* device instance $241 r0 *1 141,114.905 rppd
X$241 T013__t1 T014__t0 VSS__t227 rppd r=479.566301097 L=3.43U W=2U
* device instance $242 r0 *1 143.7,114.905 rppd
X$242 T017__t1 T016__t0 VSS__t228 rppd r=479.566301097 L=3.43U W=2U
* device instance $243 r0 *1 146.4,114.905 rppd
X$243 T043__t1 T044__t0 VSS__t229 rppd r=479.566301097 L=3.43U W=2U
* device instance $244 r0 *1 149.1,114.905 rppd
X$244 T047__t1 T046__t0 VSS__t230 rppd r=479.566301097 L=3.43U W=2U
* device instance $245 r0 *1 151.8,114.905 rppd
X$245 T073__t1 T074__t0 VSS__t231 rppd r=479.566301097 L=3.43U W=2U
* device instance $246 r0 *1 154.5,114.905 rppd
X$246 T077__t1 T076__t0 VSS__t232 rppd r=479.566301097 L=3.43U W=2U
* device instance $247 r0 *1 157.2,114.905 rppd
X$247 T103__t1 T104__t0 VSS__t233 rppd r=479.566301097 L=3.43U W=2U
* device instance $248 r0 *1 159.9,114.905 rppd
X$248 T107__t1 T106__t0 VSS__t234 rppd r=479.566301097 L=3.43U W=2U
* device instance $249 r0 *1 162.6,114.905 rppd
X$249 T133__t1 T134__t0 VSS__t235 rppd r=479.566301097 L=3.43U W=2U
* device instance $250 r0 *1 165.3,114.905 rppd
X$250 T137__t1 T136__t0 VSS__t236 rppd r=479.566301097 L=3.43U W=2U
* device instance $251 r0 *1 168,114.905 rppd
X$251 T163__t1 T164__t0 VSS__t237 rppd r=479.566301097 L=3.43U W=2U
* device instance $252 r0 *1 170.7,114.905 rppd
X$252 T167__t1 T166__t0 VSS__t238 rppd r=479.566301097 L=3.43U W=2U
* device instance $253 r0 *1 173.4,114.905 rppd
X$253 T193__t1 T194__t0 VSS__t239 rppd r=479.566301097 L=3.43U W=2U
* device instance $254 r0 *1 176.1,114.905 rppd
X$254 T197__t1 T196__t0 VSS__t240 rppd r=479.566301097 L=3.43U W=2U
* device instance $255 r0 *1 178.8,114.905 rppd
X$255 T223__t1 T224__t0 VSS__t241 rppd r=479.566301097 L=3.43U W=2U
* device instance $256 r0 *1 181.5,114.905 rppd
X$256 T227__t1 T226__t0 VSS__t242 rppd r=479.566301097 L=3.43U W=2U
* device instance $257 r0 *1 184.2,114.905 rppd
X$257 T253__t1 T254__t0 VSS__t243 rppd r=479.566301097 L=3.43U W=2U
* device instance $258 r0 *1 141,119.535 rppd
X$258 T014__t1 T001|T003|T007|T015|T031|T063|T127|TN0__t3 VSS__t244 rppd
+ r=479.566301097 L=3.43U W=2U
* device instance $259 r0 *1 143.7,119.535 rppd
X$259 T016__t1 T001|T003|T007|T015|T031|T063|T127|TN0__t4 VSS__t245 rppd
+ r=479.566301097 L=3.43U W=2U
* device instance $260 r0 *1 146.4,119.535 rppd
X$260 T044__t1 T045__t0 VSS__t246 rppd r=479.566301097 L=3.43U W=2U
* device instance $261 r0 *1 149.1,119.535 rppd
X$261 T046__t1 T045__t1 VSS__t247 rppd r=479.566301097 L=3.43U W=2U
* device instance $262 r0 *1 151.8,119.535 rppd
X$262 T074__t1 T075__t0 VSS__t248 rppd r=479.566301097 L=3.43U W=2U
* device instance $263 r0 *1 154.5,119.535 rppd
X$263 T076__t1 T075__t1 VSS__t249 rppd r=479.566301097 L=3.43U W=2U
* device instance $264 r0 *1 157.2,119.535 rppd
X$264 T104__t1 T105__t1 VSS__t250 rppd r=479.566301097 L=3.43U W=2U
* device instance $265 r0 *1 159.9,119.535 rppd
X$265 T106__t1 T105__t0 VSS__t251 rppd r=479.566301097 L=3.43U W=2U
* device instance $266 r0 *1 162.6,119.535 rppd
X$266 T134__t1 T135__t0 VSS__t252 rppd r=479.566301097 L=3.43U W=2U
* device instance $267 r0 *1 165.3,119.535 rppd
X$267 T136__t1 T135__t1 VSS__t253 rppd r=479.566301097 L=3.43U W=2U
* device instance $268 r0 *1 168,119.535 rppd
X$268 T164__t1 T165__t1 VSS__t254 rppd r=479.566301097 L=3.43U W=2U
* device instance $269 r0 *1 170.7,119.535 rppd
X$269 T166__t1 T165__t0 VSS__t255 rppd r=479.566301097 L=3.43U W=2U
* device instance $270 r0 *1 173.4,119.535 rppd
X$270 T194__t1 T195__t0 VSS__t256 rppd r=479.566301097 L=3.43U W=2U
* device instance $271 r0 *1 176.1,119.535 rppd
X$271 T196__t1 T195__t1 VSS__t257 rppd r=479.566301097 L=3.43U W=2U
* device instance $272 r0 *1 178.8,119.535 rppd
X$272 T224__t1 T225__t0 VSS__t258 rppd r=479.566301097 L=3.43U W=2U
* device instance $273 r0 *1 181.5,119.535 rppd
X$273 T226__t1 T225__t1 VSS__t259 rppd r=479.566301097 L=3.43U W=2U
* device instance $274 r0 *1 184.2,119.535 rppd
X$274 T254__t1 CB3__t0 VSS__t260 rppd r=479.566301097 L=3.43U W=2U
* device instance $275 r0 *1 232.37,79.79 rhigh
X$275 VDD__t3 DET__t1 VSS__t263 rhigh r=1999501.66667 L=1411.3U W=1U
* device instance CB2_t0 r0 *1 0,0
RCB2_t0 CB2__t0 CB2 23.0085
* device instance CB2 r0 *1 0,0
CCB2 CB2 vsubs 7.410176e-15
* device instance CB3_t0 r0 *1 0,0
RCB3_t0 CB3__t0 CB3 38.9336
* device instance CB3 r0 *1 0,0
CCB3 CB3 vsubs 1.1944554e-14
* device instance D1_t0 r0 *1 0,0
RD1_t0 D1__t0 D1 7.5611711025
* device instance D1_t1 r0 *1 0,0
RD1_t1 D1__t1 D1 7.5611711025
* device instance D1_t2 r0 *1 0,0
RD1_t2 D1__t2 D1 8.78925409256
* device instance D1_t3 r0 *1 0,0
RD1_t3 D1__t3 D1 22.2365037024
* device instance D1 r0 *1 0,0
CD1 D1 vsubs 1.6654784e-14
* device instance D2_t0 r0 *1 0,0
RD2_t0 D2__t0 D2 9.67529263899
* device instance D2_t1 r0 *1 0,0
RD2_t1 D2__t1 D2 25.3476076125
* device instance D2_t2 r0 *1 0,0
RD2_t2 D2__t2 D2 8.57969987427
* device instance D2_t3 r0 *1 0,0
RD2_t3 D2__t3 D2 8.57969987427
* device instance D2 r0 *1 0,0
CD2 D2 vsubs 1.8487849e-14
* device instance DET_t0 r0 *1 0,0
RDET_t0 DET__t0 DET 7.93106173611
* device instance DET_t1 r0 *1 0,0
RDET_t1 DET__t1 DET 9.30377337135
* device instance DET_t2 r0 *1 0,0
RDET_t2 DET__t2 DET 4.74606489254
* device instance DET r0 *1 0,0
CDET DET vsubs 5.604881e-15
* device instance FB_OUT_t0 r0 *1 0,0
RFB_OUT_t0 FB|OUT__t0 FB|OUT 8.47336272532
* device instance FB_OUT_t1 r0 *1 0,0
RFB_OUT_t1 FB|OUT__t1 FB|OUT 28.2685245288
* device instance FB_OUT_t2 r0 *1 0,0
RFB_OUT_t2 FB|OUT__t2 FB|OUT 14.6415708192
* device instance FB_OUT_t3 r0 *1 0,0
RFB_OUT_t3 FB|OUT__t3 FB|OUT 12.0221116362
* device instance FB_OUT_t4 r0 *1 0,0
RFB_OUT_t4 FB|OUT__t4 FB|OUT 4.43513194575
* device instance FB_OUT_t5 r0 *1 0,0
RFB_OUT_t5 FB|OUT__t5 FB|OUT 7.85036433359
* device instance FB_OUT_t6 r0 *1 0,0
RFB_OUT_t6 FB|OUT__t6 FB|OUT 5.7423075432
* device instance FB_OUT_t7 r0 *1 0,0
RFB_OUT_t7 FB|OUT__t7 FB|OUT 24.7589763852
* device instance FB_OUT_t8 r0 *1 0,0
RFB_OUT_t8 FB|OUT__t8 FB|OUT 9.99701552135
* device instance FB_OUT_t9 r0 *1 0,0
RFB_OUT_t9 FB|OUT__t9 FB|OUT 15.2321345614
* device instance FB_OUT r0 *1 0,0
CFB_OUT FB|OUT vsubs 3.6415544e-14
* device instance IN_N_SNS1_t0 r0 *1 0,0
RIN_N_SNS1_t0 IN_N|SNS1__t0 IN_N|SNS1 54.2966755282
* device instance IN_N_SNS1_t1 r0 *1 0,0
RIN_N_SNS1_t1 IN_N|SNS1__t1 IN_N|SNS1 37.0964878587
* device instance IN_N_SNS1_t2 r0 *1 0,0
RIN_N_SNS1_t2 IN_N|SNS1__t2 IN_N|SNS1 20.9303366131
* device instance IN_N_SNS1 r0 *1 0,0
CIN_N_SNS1 IN_N|SNS1 vsubs 2.8859197e-14
* device instance IN_P_SNS2_t0 r0 *1 0,0
RIN_P_SNS2_t0 IN_P|SNS2__t0 IN_P|SNS2 22.5415775993
* device instance IN_P_SNS2_t1 r0 *1 0,0
RIN_P_SNS2_t1 IN_P|SNS2__t1 IN_P|SNS2 4.09368781645
* device instance IN_P_SNS2_t2 r0 *1 0,0
RIN_P_SNS2_t2 IN_P|SNS2__t2 IN_P|SNS2 8.51103484455
* device instance IN_P_SNS2_t3 r0 *1 0,0
RIN_P_SNS2_t3 IN_P|SNS2__t3 IN_P|SNS2 11.5835997397
* device instance IN_P_SNS2 r0 *1 0,0
CIN_P_SNS2 IN_P|SNS2 vsubs 1.3888551e-14
* device instance PN_t0 r0 *1 0,0
RPN_t0 PN__t0 PN 7.9209950872
* device instance PN_t1 r0 *1 0,0
RPN_t1 PN__t1 PN 1.92112349438
* device instance PN_t2 r0 *1 0,0
RPN_t2 PN__t2 PN 7.9209950872
* device instance PN_t3 r0 *1 0,0
RPN_t3 PN__t3 PN 16.4140863312
* device instance PN r0 *1 0,0
CPN PN vsubs 1.1332738e-14
* device instance T001_T003_T007_T015_T031_T063_T127_TN0_t0 r0 *1 0,0
RT001_T003_T007_T015_T031_T063_T127_TN0_t0
+ T001|T003|T007|T015|T031|T063|T127|TN0__t0
+ T001|T003|T007|T015|T031|T063|T127|TN0 2.11437307947
* device instance T001_T003_T007_T015_T031_T063_T127_TN0_t1 r0 *1 0,0
RT001_T003_T007_T015_T031_T063_T127_TN0_t1
+ T001|T003|T007|T015|T031|T063|T127|TN0__t1
+ T001|T003|T007|T015|T031|T063|T127|TN0 2.11437307947
* device instance T001_T003_T007_T015_T031_T063_T127_TN0_t2 r0 *1 0,0
RT001_T003_T007_T015_T031_T063_T127_TN0_t2
+ T001|T003|T007|T015|T031|T063|T127|TN0__t2
+ T001|T003|T007|T015|T031|T063|T127|TN0 3.64129851262
* device instance T001_T003_T007_T015_T031_T063_T127_TN0_t3 r0 *1 0,0
RT001_T003_T007_T015_T031_T063_T127_TN0_t3
+ T001|T003|T007|T015|T031|T063|T127|TN0__t3
+ T001|T003|T007|T015|T031|T063|T127|TN0 4.27764381987
* device instance T001_T003_T007_T015_T031_T063_T127_TN0_t4 r0 *1 0,0
RT001_T003_T007_T015_T031_T063_T127_TN0_t4
+ T001|T003|T007|T015|T031|T063|T127|TN0__t4
+ T001|T003|T007|T015|T031|T063|T127|TN0 4.26794100965
* device instance T001_T003_T007_T015_T031_T063_T127_TN0_t5 r0 *1 0,0
RT001_T003_T007_T015_T031_T063_T127_TN0_t5
+ T001|T003|T007|T015|T031|T063|T127|TN0__t5
+ T001|T003|T007|T015|T031|T063|T127|TN0 2.1083668847
* device instance T001_T003_T007_T015_T031_T063_T127_TN0_t6 r0 *1 0,0
RT001_T003_T007_T015_T031_T063_T127_TN0_t6
+ T001|T003|T007|T015|T031|T063|T127|TN0__t6
+ T001|T003|T007|T015|T031|T063|T127|TN0 1.93726691506
* device instance T001_T003_T007_T015_T031_T063_T127_TN0_t7 r0 *1 0,0
RT001_T003_T007_T015_T031_T063_T127_TN0_t7
+ T001|T003|T007|T015|T031|T063|T127|TN0__t7
+ T001|T003|T007|T015|T031|T063|T127|TN0 1.22032207139
* device instance T001_T003_T007_T015_T031_T063_T127_TN0_t8 r0 *1 0,0
RT001_T003_T007_T015_T031_T063_T127_TN0_t8
+ T001|T003|T007|T015|T031|T063|T127|TN0__t8
+ T001|T003|T007|T015|T031|T063|T127|TN0 1.41433371914
* device instance T001_T003_T007_T015_T031_T063_T127_TN0_t9 r0 *1 0,0
RT001_T003_T007_T015_T031_T063_T127_TN0_t9
+ T001|T003|T007|T015|T031|T063|T127|TN0__t9
+ T001|T003|T007|T015|T031|T063|T127|TN0 0.695110670243
* device instance T001_T003_T007_T015_T031_T063_T127_TN0_t10 r0 *1 0,0
RT001_T003_T007_T015_T031_T063_T127_TN0_t10
+ T001|T003|T007|T015|T031|T063|T127|TN0__t10
+ T001|T003|T007|T015|T031|T063|T127|TN0 1.65770478058
* device instance T001_T003_T007_T015_T031_T063_T127_TN0_t11 r0 *1 0,0
RT001_T003_T007_T015_T031_T063_T127_TN0_t11
+ T001|T003|T007|T015|T031|T063|T127|TN0__t11
+ T001|T003|T007|T015|T031|T063|T127|TN0 1.06265803038
* device instance T001_T003_T007_T015_T031_T063_T127_TN0_t12 r0 *1 0,0
RT001_T003_T007_T015_T031_T063_T127_TN0_t12
+ T001|T003|T007|T015|T031|T063|T127|TN0__t12
+ T001|T003|T007|T015|T031|T063|T127|TN0 1.66533712449
* device instance T001_T003_T007_T015_T031_T063_T127_TN0_t13 r0 *1 0,0
RT001_T003_T007_T015_T031_T063_T127_TN0_t13
+ T001|T003|T007|T015|T031|T063|T127|TN0__t13
+ T001|T003|T007|T015|T031|T063|T127|TN0 0.786185842119
* device instance T001_T003_T007_T015_T031_T063_T127_TN0_t14 r0 *1 0,0
RT001_T003_T007_T015_T031_T063_T127_TN0_t14
+ T001|T003|T007|T015|T031|T063|T127|TN0__t14
+ T001|T003|T007|T015|T031|T063|T127|TN0 1.1244274397
* device instance T001_T003_T007_T015_T031_T063_T127_TN0_t15 r0 *1 0,0
RT001_T003_T007_T015_T031_T063_T127_TN0_t15
+ T001|T003|T007|T015|T031|T063|T127|TN0__t15
+ T001|T003|T007|T015|T031|T063|T127|TN0 2.12935702113
* device instance T001_T003_T007_T015_T031_T063_T127_TN0 r0 *1 0,0
CT001_T003_T007_T015_T031_T063_T127_TN0 T001|T003|T007|T015|T031|T063|T127|TN0
+ vsubs 2.4934244e-14
* device instance T002_t0 r0 *1 0,0
RT002_t0 T002__t0 T002 0.0275
* device instance T002_t1 r0 *1 0,0
RT002_t1 T002__t1 T002 0.0275
* device instance T002 r0 *1 0,0
CT002 T002 vsubs 3.43837e-16
* device instance T004_t0 r0 *1 0,0
RT004_t0 T004__t0 T004 0.0275
* device instance T004_t1 r0 *1 0,0
RT004_t1 T004__t1 T004 0.0275
* device instance T004 r0 *1 0,0
CT004 T004 vsubs 3.43837e-16
* device instance T005_t0 r0 *1 0,0
RT005_t0 T005__t0 T005 0.0275
* device instance T005_t1 r0 *1 0,0
RT005_t1 T005__t1 T005 0.0275
* device instance T005 r0 *1 0,0
CT005 T005 vsubs 3.43837e-16
* device instance T006_t0 r0 *1 0,0
RT006_t0 T006__t0 T006 0.0275
* device instance T006_t1 r0 *1 0,0
RT006_t1 T006__t1 T006 0.0275
* device instance T006 r0 *1 0,0
CT006 T006 vsubs 3.43837e-16
* device instance T008_t0 r0 *1 0,0
RT008_t0 T008__t0 T008 0.0275
* device instance T008_t1 r0 *1 0,0
RT008_t1 T008__t1 T008 0.0275
* device instance T008 r0 *1 0,0
CT008 T008 vsubs 3.43837e-16
* device instance T009_t0 r0 *1 0,0
RT009_t0 T009__t0 T009 0.0275
* device instance T009_t1 r0 *1 0,0
RT009_t1 T009__t1 T009 0.0275
* device instance T009 r0 *1 0,0
CT009 T009 vsubs 3.43837e-16
* device instance T010_t0 r0 *1 0,0
RT010_t0 T010__t0 T010 0.0275
* device instance T010_t1 r0 *1 0,0
RT010_t1 T010__t1 T010 0.0275
* device instance T010 r0 *1 0,0
CT010 T010 vsubs 3.43837e-16
* device instance T011_t0 r0 *1 0,0
RT011_t0 T011__t0 T011 0.0275
* device instance T011_t1 r0 *1 0,0
RT011_t1 T011__t1 T011 0.0275
* device instance T011 r0 *1 0,0
CT011 T011 vsubs 3.43837e-16
* device instance T012_t0 r0 *1 0,0
RT012_t0 T012__t0 T012 0.0275
* device instance T012_t1 r0 *1 0,0
RT012_t1 T012__t1 T012 0.0275
* device instance T012 r0 *1 0,0
CT012 T012 vsubs 3.43837e-16
* device instance T013_t0 r0 *1 0,0
RT013_t0 T013__t0 T013 0.0275
* device instance T013_t1 r0 *1 0,0
RT013_t1 T013__t1 T013 0.0275
* device instance T013 r0 *1 0,0
CT013 T013 vsubs 3.43837e-16
* device instance T014_t0 r0 *1 0,0
RT014_t0 T014__t0 T014 0.0275
* device instance T014_t1 r0 *1 0,0
RT014_t1 T014__t1 T014 0.0275
* device instance T014 r0 *1 0,0
CT014 T014 vsubs 3.43837e-16
* device instance T016_t0 r0 *1 0,0
RT016_t0 T016__t0 T016 0.0275
* device instance T016_t1 r0 *1 0,0
RT016_t1 T016__t1 T016 0.0275
* device instance T016 r0 *1 0,0
CT016 T016 vsubs 3.85855e-16
* device instance T017_t0 r0 *1 0,0
RT017_t0 T017__t0 T017 0.0275
* device instance T017_t1 r0 *1 0,0
RT017_t1 T017__t1 T017 0.0275
* device instance T017 r0 *1 0,0
CT017 T017 vsubs 3.85855e-16
* device instance T018_t0 r0 *1 0,0
RT018_t0 T018__t0 T018 0.0275
* device instance T018_t1 r0 *1 0,0
RT018_t1 T018__t1 T018 0.0275
* device instance T018 r0 *1 0,0
CT018 T018 vsubs 3.85855e-16
* device instance T019_t0 r0 *1 0,0
RT019_t0 T019__t0 T019 0.0275
* device instance T019_t1 r0 *1 0,0
RT019_t1 T019__t1 T019 0.0275
* device instance T019 r0 *1 0,0
CT019 T019 vsubs 3.85855e-16
* device instance T020_t0 r0 *1 0,0
RT020_t0 T020__t0 T020 0.0275
* device instance T020_t1 r0 *1 0,0
RT020_t1 T020__t1 T020 0.0275
* device instance T020 r0 *1 0,0
CT020 T020 vsubs 3.85855e-16
* device instance T021_t0 r0 *1 0,0
RT021_t0 T021__t0 T021 0.0275
* device instance T021_t1 r0 *1 0,0
RT021_t1 T021__t1 T021 0.0275
* device instance T021 r0 *1 0,0
CT021 T021 vsubs 3.85855e-16
* device instance T022_t0 r0 *1 0,0
RT022_t0 T022__t0 T022 0.0275
* device instance T022_t1 r0 *1 0,0
RT022_t1 T022__t1 T022 0.0275
* device instance T022 r0 *1 0,0
CT022 T022 vsubs 3.85855e-16
* device instance T023_t0 r0 *1 0,0
RT023_t0 T023__t0 T023 0.0275
* device instance T023_t1 r0 *1 0,0
RT023_t1 T023__t1 T023 0.0275
* device instance T023 r0 *1 0,0
CT023 T023 vsubs 3.85855e-16
* device instance T024_t0 r0 *1 0,0
RT024_t0 T024__t0 T024 0.0275
* device instance T024_t1 r0 *1 0,0
RT024_t1 T024__t1 T024 0.0275
* device instance T024 r0 *1 0,0
CT024 T024 vsubs 3.85855e-16
* device instance T025_t0 r0 *1 0,0
RT025_t0 T025__t0 T025 0.0275
* device instance T025_t1 r0 *1 0,0
RT025_t1 T025__t1 T025 0.0275
* device instance T025 r0 *1 0,0
CT025 T025 vsubs 3.85855e-16
* device instance T026_t0 r0 *1 0,0
RT026_t0 T026__t0 T026 0.0275
* device instance T026_t1 r0 *1 0,0
RT026_t1 T026__t1 T026 0.0275
* device instance T026 r0 *1 0,0
CT026 T026 vsubs 3.85855e-16
* device instance T027_t0 r0 *1 0,0
RT027_t0 T027__t0 T027 0.0275
* device instance T027_t1 r0 *1 0,0
RT027_t1 T027__t1 T027 0.0275
* device instance T027 r0 *1 0,0
CT027 T027 vsubs 3.85855e-16
* device instance T028_t0 r0 *1 0,0
RT028_t0 T028__t0 T028 0.0275
* device instance T028_t1 r0 *1 0,0
RT028_t1 T028__t1 T028 0.0275
* device instance T028 r0 *1 0,0
CT028 T028 vsubs 3.85855e-16
* device instance T029_t0 r0 *1 0,0
RT029_t0 T029__t0 T029 0.0275
* device instance T029_t1 r0 *1 0,0
RT029_t1 T029__t1 T029 0.0275
* device instance T029 r0 *1 0,0
CT029 T029 vsubs 3.85855e-16
* device instance T030_t0 r0 *1 0,0
RT030_t0 T030__t0 T030 0.561
* device instance T030_t1 r0 *1 0,0
RT030_t1 T030__t1 T030 0.561
* device instance T030 r0 *1 0,0
CT030 T030 vsubs 5.3264e-16
* device instance T032_t0 r0 *1 0,0
RT032_t0 T032__t0 T032 0.0275
* device instance T032_t1 r0 *1 0,0
RT032_t1 T032__t1 T032 0.0275
* device instance T032 r0 *1 0,0
CT032 T032 vsubs 3.43837e-16
* device instance T033_t0 r0 *1 0,0
RT033_t0 T033__t0 T033 0.0275
* device instance T033_t1 r0 *1 0,0
RT033_t1 T033__t1 T033 0.0275
* device instance T033 r0 *1 0,0
CT033 T033 vsubs 3.43837e-16
* device instance T034_t0 r0 *1 0,0
RT034_t0 T034__t0 T034 0.0275
* device instance T034_t1 r0 *1 0,0
RT034_t1 T034__t1 T034 0.0275
* device instance T034 r0 *1 0,0
CT034 T034 vsubs 3.43837e-16
* device instance T035_t0 r0 *1 0,0
RT035_t0 T035__t0 T035 0.0275
* device instance T035_t1 r0 *1 0,0
RT035_t1 T035__t1 T035 0.0275
* device instance T035 r0 *1 0,0
CT035 T035 vsubs 3.43837e-16
* device instance T036_t0 r0 *1 0,0
RT036_t0 T036__t0 T036 0.0275
* device instance T036_t1 r0 *1 0,0
RT036_t1 T036__t1 T036 0.0275
* device instance T036 r0 *1 0,0
CT036 T036 vsubs 3.43837e-16
* device instance T037_t0 r0 *1 0,0
RT037_t0 T037__t0 T037 0.0275
* device instance T037_t1 r0 *1 0,0
RT037_t1 T037__t1 T037 0.0275
* device instance T037 r0 *1 0,0
CT037 T037 vsubs 3.43837e-16
* device instance T038_t0 r0 *1 0,0
RT038_t0 T038__t0 T038 0.0275
* device instance T038_t1 r0 *1 0,0
RT038_t1 T038__t1 T038 0.0275
* device instance T038 r0 *1 0,0
CT038 T038 vsubs 3.43837e-16
* device instance T039_t0 r0 *1 0,0
RT039_t0 T039__t0 T039 0.0275
* device instance T039_t1 r0 *1 0,0
RT039_t1 T039__t1 T039 0.0275
* device instance T039 r0 *1 0,0
CT039 T039 vsubs 3.43837e-16
* device instance T040_t0 r0 *1 0,0
RT040_t0 T040__t0 T040 0.0275
* device instance T040_t1 r0 *1 0,0
RT040_t1 T040__t1 T040 0.0275
* device instance T040 r0 *1 0,0
CT040 T040 vsubs 3.43837e-16
* device instance T041_t0 r0 *1 0,0
RT041_t0 T041__t0 T041 0.0275
* device instance T041_t1 r0 *1 0,0
RT041_t1 T041__t1 T041 0.0275
* device instance T041 r0 *1 0,0
CT041 T041 vsubs 3.43837e-16
* device instance T042_t0 r0 *1 0,0
RT042_t0 T042__t0 T042 0.0275
* device instance T042_t1 r0 *1 0,0
RT042_t1 T042__t1 T042 0.0275
* device instance T042 r0 *1 0,0
CT042 T042 vsubs 3.43837e-16
* device instance T043_t0 r0 *1 0,0
RT043_t0 T043__t0 T043 0.0275
* device instance T043_t1 r0 *1 0,0
RT043_t1 T043__t1 T043 0.0275
* device instance T043 r0 *1 0,0
CT043 T043 vsubs 3.43837e-16
* device instance T044_t0 r0 *1 0,0
RT044_t0 T044__t0 T044 0.0275
* device instance T044_t1 r0 *1 0,0
RT044_t1 T044__t1 T044 0.0275
* device instance T044 r0 *1 0,0
CT044 T044 vsubs 3.43837e-16
* device instance T045_t0 r0 *1 0,0
RT045_t0 T045__t0 T045 0.561
* device instance T045_t1 r0 *1 0,0
RT045_t1 T045__t1 T045 0.561
* device instance T045 r0 *1 0,0
CT045 T045 vsubs 5.07254e-16
* device instance T046_t0 r0 *1 0,0
RT046_t0 T046__t0 T046 0.0275
* device instance T046_t1 r0 *1 0,0
RT046_t1 T046__t1 T046 0.0275
* device instance T046 r0 *1 0,0
CT046 T046 vsubs 3.85855e-16
* device instance T047_t0 r0 *1 0,0
RT047_t0 T047__t0 T047 0.0275
* device instance T047_t1 r0 *1 0,0
RT047_t1 T047__t1 T047 0.0275
* device instance T047 r0 *1 0,0
CT047 T047 vsubs 3.85855e-16
* device instance T048_t0 r0 *1 0,0
RT048_t0 T048__t0 T048 0.0275
* device instance T048_t1 r0 *1 0,0
RT048_t1 T048__t1 T048 0.0275
* device instance T048 r0 *1 0,0
CT048 T048 vsubs 3.85855e-16
* device instance T049_t0 r0 *1 0,0
RT049_t0 T049__t0 T049 0.0275
* device instance T049_t1 r0 *1 0,0
RT049_t1 T049__t1 T049 0.0275
* device instance T049 r0 *1 0,0
CT049 T049 vsubs 3.85855e-16
* device instance T050_t0 r0 *1 0,0
RT050_t0 T050__t0 T050 0.0275
* device instance T050_t1 r0 *1 0,0
RT050_t1 T050__t1 T050 0.0275
* device instance T050 r0 *1 0,0
CT050 T050 vsubs 3.85855e-16
* device instance T051_t0 r0 *1 0,0
RT051_t0 T051__t0 T051 0.0275
* device instance T051_t1 r0 *1 0,0
RT051_t1 T051__t1 T051 0.0275
* device instance T051 r0 *1 0,0
CT051 T051 vsubs 3.85855e-16
* device instance T052_t0 r0 *1 0,0
RT052_t0 T052__t0 T052 0.0275
* device instance T052_t1 r0 *1 0,0
RT052_t1 T052__t1 T052 0.0275
* device instance T052 r0 *1 0,0
CT052 T052 vsubs 3.85855e-16
* device instance T053_t0 r0 *1 0,0
RT053_t0 T053__t0 T053 0.0275
* device instance T053_t1 r0 *1 0,0
RT053_t1 T053__t1 T053 0.0275
* device instance T053 r0 *1 0,0
CT053 T053 vsubs 3.85855e-16
* device instance T054_t0 r0 *1 0,0
RT054_t0 T054__t0 T054 0.0275
* device instance T054_t1 r0 *1 0,0
RT054_t1 T054__t1 T054 0.0275
* device instance T054 r0 *1 0,0
CT054 T054 vsubs 3.85855e-16
* device instance T055_t0 r0 *1 0,0
RT055_t0 T055__t0 T055 0.0275
* device instance T055_t1 r0 *1 0,0
RT055_t1 T055__t1 T055 0.0275
* device instance T055 r0 *1 0,0
CT055 T055 vsubs 3.85855e-16
* device instance T056_t0 r0 *1 0,0
RT056_t0 T056__t0 T056 0.0275
* device instance T056_t1 r0 *1 0,0
RT056_t1 T056__t1 T056 0.0275
* device instance T056 r0 *1 0,0
CT056 T056 vsubs 3.85855e-16
* device instance T057_t0 r0 *1 0,0
RT057_t0 T057__t0 T057 0.0275
* device instance T057_t1 r0 *1 0,0
RT057_t1 T057__t1 T057 0.0275
* device instance T057 r0 *1 0,0
CT057 T057 vsubs 3.85855e-16
* device instance T058_t0 r0 *1 0,0
RT058_t0 T058__t0 T058 0.0275
* device instance T058_t1 r0 *1 0,0
RT058_t1 T058__t1 T058 0.0275
* device instance T058 r0 *1 0,0
CT058 T058 vsubs 3.85855e-16
* device instance T059_t0 r0 *1 0,0
RT059_t0 T059__t0 T059 0.0275
* device instance T059_t1 r0 *1 0,0
RT059_t1 T059__t1 T059 0.0275
* device instance T059 r0 *1 0,0
CT059 T059 vsubs 3.22828e-16
* device instance T060_t0 r0 *1 0,0
RT060_t0 T060__t0 T060 0.561
* device instance T060_t1 r0 *1 0,0
RT060_t1 T060__t1 T060 0.561
* device instance T060 r0 *1 0,0
CT060 T060 vsubs 5.3264e-16
* device instance T061_t0 r0 *1 0,0
RT061_t0 T061__t0 T061 0.0275
* device instance T061_t1 r0 *1 0,0
RT061_t1 T061__t1 T061 0.0275
* device instance T061 r0 *1 0,0
CT061 T061 vsubs 3.29831e-16
* device instance T062_t0 r0 *1 0,0
RT062_t0 T062__t0 T062 0.0275
* device instance T062_t1 r0 *1 0,0
RT062_t1 T062__t1 T062 0.0275
* device instance T062 r0 *1 0,0
CT062 T062 vsubs 3.43837e-16
* device instance T064_t0 r0 *1 0,0
RT064_t0 T064__t0 T064 0.0275
* device instance T064_t1 r0 *1 0,0
RT064_t1 T064__t1 T064 0.0275
* device instance T064 r0 *1 0,0
CT064 T064 vsubs 3.85855e-16
* device instance T065_t0 r0 *1 0,0
RT065_t0 T065__t0 T065 0.0275
* device instance T065_t1 r0 *1 0,0
RT065_t1 T065__t1 T065 0.0275
* device instance T065 r0 *1 0,0
CT065 T065 vsubs 3.85855e-16
* device instance T066_t0 r0 *1 0,0
RT066_t0 T066__t0 T066 0.0275
* device instance T066_t1 r0 *1 0,0
RT066_t1 T066__t1 T066 0.0275
* device instance T066 r0 *1 0,0
CT066 T066 vsubs 3.85855e-16
* device instance T067_t0 r0 *1 0,0
RT067_t0 T067__t0 T067 0.0275
* device instance T067_t1 r0 *1 0,0
RT067_t1 T067__t1 T067 0.0275
* device instance T067 r0 *1 0,0
CT067 T067 vsubs 3.85855e-16
* device instance T068_t0 r0 *1 0,0
RT068_t0 T068__t0 T068 0.0275
* device instance T068_t1 r0 *1 0,0
RT068_t1 T068__t1 T068 0.0275
* device instance T068 r0 *1 0,0
CT068 T068 vsubs 3.85855e-16
* device instance T069_t0 r0 *1 0,0
RT069_t0 T069__t0 T069 0.0275
* device instance T069_t1 r0 *1 0,0
RT069_t1 T069__t1 T069 0.0275
* device instance T069 r0 *1 0,0
CT069 T069 vsubs 3.85855e-16
* device instance T070_t0 r0 *1 0,0
RT070_t0 T070__t0 T070 0.0275
* device instance T070_t1 r0 *1 0,0
RT070_t1 T070__t1 T070 0.0275
* device instance T070 r0 *1 0,0
CT070 T070 vsubs 3.85855e-16
* device instance T071_t0 r0 *1 0,0
RT071_t0 T071__t0 T071 0.0275
* device instance T071_t1 r0 *1 0,0
RT071_t1 T071__t1 T071 0.0275
* device instance T071 r0 *1 0,0
CT071 T071 vsubs 3.85855e-16
* device instance T072_t0 r0 *1 0,0
RT072_t0 T072__t0 T072 0.0275
* device instance T072_t1 r0 *1 0,0
RT072_t1 T072__t1 T072 0.0275
* device instance T072 r0 *1 0,0
CT072 T072 vsubs 3.85855e-16
* device instance T073_t0 r0 *1 0,0
RT073_t0 T073__t0 T073 0.0275
* device instance T073_t1 r0 *1 0,0
RT073_t1 T073__t1 T073 0.0275
* device instance T073 r0 *1 0,0
CT073 T073 vsubs 3.85855e-16
* device instance T074_t0 r0 *1 0,0
RT074_t0 T074__t0 T074 0.0275
* device instance T074_t1 r0 *1 0,0
RT074_t1 T074__t1 T074 0.0275
* device instance T074 r0 *1 0,0
CT074 T074 vsubs 3.85855e-16
* device instance T075_t0 r0 *1 0,0
RT075_t0 T075__t0 T075 0.561
* device instance T075_t1 r0 *1 0,0
RT075_t1 T075__t1 T075 0.561
* device instance T075 r0 *1 0,0
CT075 T075 vsubs 5.3264e-16
* device instance T076_t0 r0 *1 0,0
RT076_t0 T076__t0 T076 0.0275
* device instance T076_t1 r0 *1 0,0
RT076_t1 T076__t1 T076 0.0275
* device instance T076 r0 *1 0,0
CT076 T076 vsubs 3.85855e-16
* device instance T077_t0 r0 *1 0,0
RT077_t0 T077__t0 T077 0.0275
* device instance T077_t1 r0 *1 0,0
RT077_t1 T077__t1 T077 0.0275
* device instance T077 r0 *1 0,0
CT077 T077 vsubs 3.85855e-16
* device instance T078_t0 r0 *1 0,0
RT078_t0 T078__t0 T078 0.0275
* device instance T078_t1 r0 *1 0,0
RT078_t1 T078__t1 T078 0.0275
* device instance T078 r0 *1 0,0
CT078 T078 vsubs 3.85855e-16
* device instance T079_t0 r0 *1 0,0
RT079_t0 T079__t0 T079 0.0275
* device instance T079_t1 r0 *1 0,0
RT079_t1 T079__t1 T079 0.0275
* device instance T079 r0 *1 0,0
CT079 T079 vsubs 3.85855e-16
* device instance T080_t0 r0 *1 0,0
RT080_t0 T080__t0 T080 0.0275
* device instance T080_t1 r0 *1 0,0
RT080_t1 T080__t1 T080 0.0275
* device instance T080 r0 *1 0,0
CT080 T080 vsubs 3.85855e-16
* device instance T081_t0 r0 *1 0,0
RT081_t0 T081__t0 T081 0.0275
* device instance T081_t1 r0 *1 0,0
RT081_t1 T081__t1 T081 0.0275
* device instance T081 r0 *1 0,0
CT081 T081 vsubs 3.85855e-16
* device instance T082_t0 r0 *1 0,0
RT082_t0 T082__t0 T082 0.0275
* device instance T082_t1 r0 *1 0,0
RT082_t1 T082__t1 T082 0.0275
* device instance T082 r0 *1 0,0
CT082 T082 vsubs 3.85855e-16
* device instance T083_t0 r0 *1 0,0
RT083_t0 T083__t0 T083 0.0275
* device instance T083_t1 r0 *1 0,0
RT083_t1 T083__t1 T083 0.0275
* device instance T083 r0 *1 0,0
CT083 T083 vsubs 3.85855e-16
* device instance T084_t0 r0 *1 0,0
RT084_t0 T084__t0 T084 0.0275
* device instance T084_t1 r0 *1 0,0
RT084_t1 T084__t1 T084 0.0275
* device instance T084 r0 *1 0,0
CT084 T084 vsubs 3.85855e-16
* device instance T085_t0 r0 *1 0,0
RT085_t0 T085__t0 T085 0.0275
* device instance T085_t1 r0 *1 0,0
RT085_t1 T085__t1 T085 0.0275
* device instance T085 r0 *1 0,0
CT085 T085 vsubs 3.85855e-16
* device instance T086_t0 r0 *1 0,0
RT086_t0 T086__t0 T086 0.0275
* device instance T086_t1 r0 *1 0,0
RT086_t1 T086__t1 T086 0.0275
* device instance T086 r0 *1 0,0
CT086 T086 vsubs 3.85855e-16
* device instance T087_t0 r0 *1 0,0
RT087_t0 T087__t0 T087 0.0275
* device instance T087_t1 r0 *1 0,0
RT087_t1 T087__t1 T087 0.0275
* device instance T087 r0 *1 0,0
CT087 T087 vsubs 3.22828e-16
* device instance T088_t0 r0 *1 0,0
RT088_t0 T088__t0 T088 0.0275
* device instance T088_t1 r0 *1 0,0
RT088_t1 T088__t1 T088 0.0275
* device instance T088 r0 *1 0,0
CT088 T088 vsubs 3.85855e-16
* device instance T089_t0 r0 *1 0,0
RT089_t0 T089__t0 T089 0.0275
* device instance T089_t1 r0 *1 0,0
RT089_t1 T089__t1 T089 0.0275
* device instance T089 r0 *1 0,0
CT089 T089 vsubs 3.85855e-16
* device instance T090_t0 r0 *1 0,0
RT090_t0 T090__t0 T090 0.561
* device instance T090_t1 r0 *1 0,0
RT090_t1 T090__t1 T090 0.561
* device instance T090 r0 *1 0,0
CT090 T090 vsubs 5.3264e-16
* device instance T091_t0 r0 *1 0,0
RT091_t0 T091__t0 T091 0.0275
* device instance T091_t1 r0 *1 0,0
RT091_t1 T091__t1 T091 0.0275
* device instance T091 r0 *1 0,0
CT091 T091 vsubs 3.85855e-16
* device instance T092_t0 r0 *1 0,0
RT092_t0 T092__t0 T092 0.0275
* device instance T092_t1 r0 *1 0,0
RT092_t1 T092__t1 T092 0.0275
* device instance T092 r0 *1 0,0
CT092 T092 vsubs 3.85855e-16
* device instance T093_t0 r0 *1 0,0
RT093_t0 T093__t0 T093 0.0275
* device instance T093_t1 r0 *1 0,0
RT093_t1 T093__t1 T093 0.0275
* device instance T093 r0 *1 0,0
CT093 T093 vsubs 3.22828e-16
* device instance T094_t0 r0 *1 0,0
RT094_t0 T094__t0 T094 0.0275
* device instance T094_t1 r0 *1 0,0
RT094_t1 T094__t1 T094 0.0275
* device instance T094 r0 *1 0,0
CT094 T094 vsubs 3.85855e-16
* device instance T095_t0 r0 *1 0,0
RT095_t0 T095__t0 T095 0.0275
* device instance T095_t1 r0 *1 0,0
RT095_t1 T095__t1 T095 0.0275
* device instance T095 r0 *1 0,0
CT095 T095 vsubs 3.85855e-16
* device instance T096_t0 r0 *1 0,0
RT096_t0 T096__t0 T096 0.0275
* device instance T096_t1 r0 *1 0,0
RT096_t1 T096__t1 T096 0.0275
* device instance T096 r0 *1 0,0
CT096 T096 vsubs 3.85855e-16
* device instance T097_t0 r0 *1 0,0
RT097_t0 T097__t0 T097 0.0275
* device instance T097_t1 r0 *1 0,0
RT097_t1 T097__t1 T097 0.0275
* device instance T097 r0 *1 0,0
CT097 T097 vsubs 3.85855e-16
* device instance T098_t0 r0 *1 0,0
RT098_t0 T098__t0 T098 0.0275
* device instance T098_t1 r0 *1 0,0
RT098_t1 T098__t1 T098 0.0275
* device instance T098 r0 *1 0,0
CT098 T098 vsubs 3.85855e-16
* device instance T099_t0 r0 *1 0,0
RT099_t0 T099__t0 T099 0.0275
* device instance T099_t1 r0 *1 0,0
RT099_t1 T099__t1 T099 0.0275
* device instance T099 r0 *1 0,0
CT099 T099 vsubs 3.85855e-16
* device instance T100_t0 r0 *1 0,0
RT100_t0 T100__t0 T100 0.0275
* device instance T100_t1 r0 *1 0,0
RT100_t1 T100__t1 T100 0.0275
* device instance T100 r0 *1 0,0
CT100 T100 vsubs 3.85855e-16
* device instance T101_t0 r0 *1 0,0
RT101_t0 T101__t0 T101 0.0275
* device instance T101_t1 r0 *1 0,0
RT101_t1 T101__t1 T101 0.0275
* device instance T101 r0 *1 0,0
CT101 T101 vsubs 3.85855e-16
* device instance T102_t0 r0 *1 0,0
RT102_t0 T102__t0 T102 0.0275
* device instance T102_t1 r0 *1 0,0
RT102_t1 T102__t1 T102 0.0275
* device instance T102 r0 *1 0,0
CT102 T102 vsubs 3.85855e-16
* device instance T103_t0 r0 *1 0,0
RT103_t0 T103__t0 T103 0.0275
* device instance T103_t1 r0 *1 0,0
RT103_t1 T103__t1 T103 0.0275
* device instance T103 r0 *1 0,0
CT103 T103 vsubs 3.85855e-16
* device instance T104_t0 r0 *1 0,0
RT104_t0 T104__t0 T104 0.0275
* device instance T104_t1 r0 *1 0,0
RT104_t1 T104__t1 T104 0.0275
* device instance T104 r0 *1 0,0
CT104 T104 vsubs 3.85855e-16
* device instance T105_t0 r0 *1 0,0
RT105_t0 T105__t0 T105 0.561
* device instance T105_t1 r0 *1 0,0
RT105_t1 T105__t1 T105 0.561
* device instance T105 r0 *1 0,0
CT105 T105 vsubs 5.3264e-16
* device instance T106_t0 r0 *1 0,0
RT106_t0 T106__t0 T106 0.0275
* device instance T106_t1 r0 *1 0,0
RT106_t1 T106__t1 T106 0.0275
* device instance T106 r0 *1 0,0
CT106 T106 vsubs 3.85855e-16
* device instance T107_t0 r0 *1 0,0
RT107_t0 T107__t0 T107 0.0275
* device instance T107_t1 r0 *1 0,0
RT107_t1 T107__t1 T107 0.0275
* device instance T107 r0 *1 0,0
CT107 T107 vsubs 3.85855e-16
* device instance T108_t0 r0 *1 0,0
RT108_t0 T108__t0 T108 0.0275
* device instance T108_t1 r0 *1 0,0
RT108_t1 T108__t1 T108 0.0275
* device instance T108 r0 *1 0,0
CT108 T108 vsubs 3.85855e-16
* device instance T109_t0 r0 *1 0,0
RT109_t0 T109__t0 T109 0.0275
* device instance T109_t1 r0 *1 0,0
RT109_t1 T109__t1 T109 0.0275
* device instance T109 r0 *1 0,0
CT109 T109 vsubs 3.85855e-16
* device instance T110_t0 r0 *1 0,0
RT110_t0 T110__t0 T110 0.0275
* device instance T110_t1 r0 *1 0,0
RT110_t1 T110__t1 T110 0.0275
* device instance T110 r0 *1 0,0
CT110 T110 vsubs 3.85855e-16
* device instance T111_t0 r0 *1 0,0
RT111_t0 T111__t0 T111 0.0275
* device instance T111_t1 r0 *1 0,0
RT111_t1 T111__t1 T111 0.0275
* device instance T111 r0 *1 0,0
CT111 T111 vsubs 3.85855e-16
* device instance T112_t0 r0 *1 0,0
RT112_t0 T112__t0 T112 0.0275
* device instance T112_t1 r0 *1 0,0
RT112_t1 T112__t1 T112 0.0275
* device instance T112 r0 *1 0,0
CT112 T112 vsubs 3.85855e-16
* device instance T113_t0 r0 *1 0,0
RT113_t0 T113__t0 T113 0.0275
* device instance T113_t1 r0 *1 0,0
RT113_t1 T113__t1 T113 0.0275
* device instance T113 r0 *1 0,0
CT113 T113 vsubs 3.85855e-16
* device instance T114_t0 r0 *1 0,0
RT114_t0 T114__t0 T114 0.0275
* device instance T114_t1 r0 *1 0,0
RT114_t1 T114__t1 T114 0.0275
* device instance T114 r0 *1 0,0
CT114 T114 vsubs 3.85855e-16
* device instance T115_t0 r0 *1 0,0
RT115_t0 T115__t0 T115 0.0275
* device instance T115_t1 r0 *1 0,0
RT115_t1 T115__t1 T115 0.0275
* device instance T115 r0 *1 0,0
CT115 T115 vsubs 3.85855e-16
* device instance T116_t0 r0 *1 0,0
RT116_t0 T116__t0 T116 0.0275
* device instance T116_t1 r0 *1 0,0
RT116_t1 T116__t1 T116 0.0275
* device instance T116 r0 *1 0,0
CT116 T116 vsubs 3.85855e-16
* device instance T117_t0 r0 *1 0,0
RT117_t0 T117__t0 T117 0.0275
* device instance T117_t1 r0 *1 0,0
RT117_t1 T117__t1 T117 0.0275
* device instance T117 r0 *1 0,0
CT117 T117 vsubs 3.22828e-16
* device instance T118_t0 r0 *1 0,0
RT118_t0 T118__t0 T118 0.0275
* device instance T118_t1 r0 *1 0,0
RT118_t1 T118__t1 T118 0.0275
* device instance T118 r0 *1 0,0
CT118 T118 vsubs 3.85855e-16
* device instance T119_t0 r0 *1 0,0
RT119_t0 T119__t0 T119 0.0275
* device instance T119_t1 r0 *1 0,0
RT119_t1 T119__t1 T119 0.0275
* device instance T119 r0 *1 0,0
CT119 T119 vsubs 3.85855e-16
* device instance T120_t0 r0 *1 0,0
RT120_t0 T120__t0 T120 0.561
* device instance T120_t1 r0 *1 0,0
RT120_t1 T120__t1 T120 0.561
* device instance T120 r0 *1 0,0
CT120 T120 vsubs 5.3264e-16
* device instance T121_t0 r0 *1 0,0
RT121_t0 T121__t0 T121 0.0275
* device instance T121_t1 r0 *1 0,0
RT121_t1 T121__t1 T121 0.0275
* device instance T121 r0 *1 0,0
CT121 T121 vsubs 3.85855e-16
* device instance T122_t0 r0 *1 0,0
RT122_t0 T122__t0 T122 0.0275
* device instance T122_t1 r0 *1 0,0
RT122_t1 T122__t1 T122 0.0275
* device instance T122 r0 *1 0,0
CT122 T122 vsubs 3.85855e-16
* device instance T123_t0 r0 *1 0,0
RT123_t0 T123__t0 T123 0.0275
* device instance T123_t1 r0 *1 0,0
RT123_t1 T123__t1 T123 0.0275
* device instance T123 r0 *1 0,0
CT123 T123 vsubs 3.29831e-16
* device instance T124_t0 r0 *1 0,0
RT124_t0 T124__t0 T124 0.0275
* device instance T124_t1 r0 *1 0,0
RT124_t1 T124__t1 T124 0.0275
* device instance T124 r0 *1 0,0
CT124 T124 vsubs 3.43837e-16
* device instance T125_t0 r0 *1 0,0
RT125_t0 T125__t0 T125 0.0275
* device instance T125_t1 r0 *1 0,0
RT125_t1 T125__t1 T125 0.0275
* device instance T125 r0 *1 0,0
CT125 T125 vsubs 3.43837e-16
* device instance T126_t0 r0 *1 0,0
RT126_t0 T126__t0 T126 0.0275
* device instance T126_t1 r0 *1 0,0
RT126_t1 T126__t1 T126 0.0275
* device instance T126 r0 *1 0,0
CT126 T126 vsubs 3.43837e-16
* device instance T128_t0 r0 *1 0,0
RT128_t0 T128__t0 T128 0.0275
* device instance T128_t1 r0 *1 0,0
RT128_t1 T128__t1 T128 0.0275
* device instance T128 r0 *1 0,0
CT128 T128 vsubs 3.85855e-16
* device instance T129_t0 r0 *1 0,0
RT129_t0 T129__t0 T129 0.0275
* device instance T129_t1 r0 *1 0,0
RT129_t1 T129__t1 T129 0.0275
* device instance T129 r0 *1 0,0
CT129 T129 vsubs 3.85855e-16
* device instance T130_t0 r0 *1 0,0
RT130_t0 T130__t0 T130 0.0275
* device instance T130_t1 r0 *1 0,0
RT130_t1 T130__t1 T130 0.0275
* device instance T130 r0 *1 0,0
CT130 T130 vsubs 3.85855e-16
* device instance T131_t0 r0 *1 0,0
RT131_t0 T131__t0 T131 0.0275
* device instance T131_t1 r0 *1 0,0
RT131_t1 T131__t1 T131 0.0275
* device instance T131 r0 *1 0,0
CT131 T131 vsubs 3.85855e-16
* device instance T132_t0 r0 *1 0,0
RT132_t0 T132__t0 T132 0.0275
* device instance T132_t1 r0 *1 0,0
RT132_t1 T132__t1 T132 0.0275
* device instance T132 r0 *1 0,0
CT132 T132 vsubs 3.85855e-16
* device instance T133_t0 r0 *1 0,0
RT133_t0 T133__t0 T133 0.0275
* device instance T133_t1 r0 *1 0,0
RT133_t1 T133__t1 T133 0.0275
* device instance T133 r0 *1 0,0
CT133 T133 vsubs 3.85855e-16
* device instance T134_t0 r0 *1 0,0
RT134_t0 T134__t0 T134 0.0275
* device instance T134_t1 r0 *1 0,0
RT134_t1 T134__t1 T134 0.0275
* device instance T134 r0 *1 0,0
CT134 T134 vsubs 3.85855e-16
* device instance T135_t0 r0 *1 0,0
RT135_t0 T135__t0 T135 0.561
* device instance T135_t1 r0 *1 0,0
RT135_t1 T135__t1 T135 0.561
* device instance T135 r0 *1 0,0
CT135 T135 vsubs 5.3264e-16
* device instance T136_t0 r0 *1 0,0
RT136_t0 T136__t0 T136 0.0275
* device instance T136_t1 r0 *1 0,0
RT136_t1 T136__t1 T136 0.0275
* device instance T136 r0 *1 0,0
CT136 T136 vsubs 3.85855e-16
* device instance T137_t0 r0 *1 0,0
RT137_t0 T137__t0 T137 0.0275
* device instance T137_t1 r0 *1 0,0
RT137_t1 T137__t1 T137 0.0275
* device instance T137 r0 *1 0,0
CT137 T137 vsubs 3.85855e-16
* device instance T138_t0 r0 *1 0,0
RT138_t0 T138__t0 T138 0.0275
* device instance T138_t1 r0 *1 0,0
RT138_t1 T138__t1 T138 0.0275
* device instance T138 r0 *1 0,0
CT138 T138 vsubs 3.85855e-16
* device instance T139_t0 r0 *1 0,0
RT139_t0 T139__t0 T139 0.0275
* device instance T139_t1 r0 *1 0,0
RT139_t1 T139__t1 T139 0.0275
* device instance T139 r0 *1 0,0
CT139 T139 vsubs 3.85855e-16
* device instance T140_t0 r0 *1 0,0
RT140_t0 T140__t0 T140 0.0275
* device instance T140_t1 r0 *1 0,0
RT140_t1 T140__t1 T140 0.0275
* device instance T140 r0 *1 0,0
CT140 T140 vsubs 3.85855e-16
* device instance T141_t0 r0 *1 0,0
RT141_t0 T141__t0 T141 0.0275
* device instance T141_t1 r0 *1 0,0
RT141_t1 T141__t1 T141 0.0275
* device instance T141 r0 *1 0,0
CT141 T141 vsubs 3.85855e-16
* device instance T142_t0 r0 *1 0,0
RT142_t0 T142__t0 T142 0.0275
* device instance T142_t1 r0 *1 0,0
RT142_t1 T142__t1 T142 0.0275
* device instance T142 r0 *1 0,0
CT142 T142 vsubs 3.85855e-16
* device instance T143_t0 r0 *1 0,0
RT143_t0 T143__t0 T143 0.0275
* device instance T143_t1 r0 *1 0,0
RT143_t1 T143__t1 T143 0.0275
* device instance T143 r0 *1 0,0
CT143 T143 vsubs 3.85855e-16
* device instance T144_t0 r0 *1 0,0
RT144_t0 T144__t0 T144 0.0275
* device instance T144_t1 r0 *1 0,0
RT144_t1 T144__t1 T144 0.0275
* device instance T144 r0 *1 0,0
CT144 T144 vsubs 3.85855e-16
* device instance T145_t0 r0 *1 0,0
RT145_t0 T145__t0 T145 0.0275
* device instance T145_t1 r0 *1 0,0
RT145_t1 T145__t1 T145 0.0275
* device instance T145 r0 *1 0,0
CT145 T145 vsubs 3.85855e-16
* device instance T146_t0 r0 *1 0,0
RT146_t0 T146__t0 T146 0.0275
* device instance T146_t1 r0 *1 0,0
RT146_t1 T146__t1 T146 0.0275
* device instance T146 r0 *1 0,0
CT146 T146 vsubs 3.85855e-16
* device instance T147_t0 r0 *1 0,0
RT147_t0 T147__t0 T147 0.0275
* device instance T147_t1 r0 *1 0,0
RT147_t1 T147__t1 T147 0.0275
* device instance T147 r0 *1 0,0
CT147 T147 vsubs 3.85855e-16
* device instance T148_t0 r0 *1 0,0
RT148_t0 T148__t0 T148 0.0275
* device instance T148_t1 r0 *1 0,0
RT148_t1 T148__t1 T148 0.0275
* device instance T148 r0 *1 0,0
CT148 T148 vsubs 3.85855e-16
* device instance T149_t0 r0 *1 0,0
RT149_t0 T149__t0 T149 0.0275
* device instance T149_t1 r0 *1 0,0
RT149_t1 T149__t1 T149 0.0275
* device instance T149 r0 *1 0,0
CT149 T149 vsubs 3.85855e-16
* device instance T150_t0 r0 *1 0,0
RT150_t0 T150__t0 T150 0.561
* device instance T150_t1 r0 *1 0,0
RT150_t1 T150__t1 T150 0.561
* device instance T150 r0 *1 0,0
CT150 T150 vsubs 5.3264e-16
* device instance T151_t0 r0 *1 0,0
RT151_t0 T151__t0 T151 0.0275
* device instance T151_t1 r0 *1 0,0
RT151_t1 T151__t1 T151 0.0275
* device instance T151 r0 *1 0,0
CT151 T151 vsubs 3.85855e-16
* device instance T152_t0 r0 *1 0,0
RT152_t0 T152__t0 T152 0.0275
* device instance T152_t1 r0 *1 0,0
RT152_t1 T152__t1 T152 0.0275
* device instance T152 r0 *1 0,0
CT152 T152 vsubs 3.85855e-16
* device instance T153_t0 r0 *1 0,0
RT153_t0 T153__t0 T153 0.0275
* device instance T153_t1 r0 *1 0,0
RT153_t1 T153__t1 T153 0.0275
* device instance T153 r0 *1 0,0
CT153 T153 vsubs 3.85855e-16
* device instance T154_t0 r0 *1 0,0
RT154_t0 T154__t0 T154 0.0275
* device instance T154_t1 r0 *1 0,0
RT154_t1 T154__t1 T154 0.0275
* device instance T154 r0 *1 0,0
CT154 T154 vsubs 3.85855e-16
* device instance T155_t0 r0 *1 0,0
RT155_t0 T155__t0 T155 0.0275
* device instance T155_t1 r0 *1 0,0
RT155_t1 T155__t1 T155 0.0275
* device instance T155 r0 *1 0,0
CT155 T155 vsubs 3.85855e-16
* device instance T156_t0 r0 *1 0,0
RT156_t0 T156__t0 T156 0.0275
* device instance T156_t1 r0 *1 0,0
RT156_t1 T156__t1 T156 0.0275
* device instance T156 r0 *1 0,0
CT156 T156 vsubs 3.85855e-16
* device instance T157_t0 r0 *1 0,0
RT157_t0 T157__t0 T157 0.0275
* device instance T157_t1 r0 *1 0,0
RT157_t1 T157__t1 T157 0.0275
* device instance T157 r0 *1 0,0
CT157 T157 vsubs 3.85855e-16
* device instance T158_t0 r0 *1 0,0
RT158_t0 T158__t0 T158 0.0275
* device instance T158_t1 r0 *1 0,0
RT158_t1 T158__t1 T158 0.0275
* device instance T158 r0 *1 0,0
CT158 T158 vsubs 3.85855e-16
* device instance T159_t0 r0 *1 0,0
RT159_t0 T159__t0 T159 0.0275
* device instance T159_t1 r0 *1 0,0
RT159_t1 T159__t1 T159 0.0275
* device instance T159 r0 *1 0,0
CT159 T159 vsubs 3.85855e-16
* device instance T160_t0 r0 *1 0,0
RT160_t0 T160__t0 T160 0.0275
* device instance T160_t1 r0 *1 0,0
RT160_t1 T160__t1 T160 0.0275
* device instance T160 r0 *1 0,0
CT160 T160 vsubs 3.85855e-16
* device instance T161_t0 r0 *1 0,0
RT161_t0 T161__t0 T161 0.0275
* device instance T161_t1 r0 *1 0,0
RT161_t1 T161__t1 T161 0.0275
* device instance T161 r0 *1 0,0
CT161 T161 vsubs 3.85855e-16
* device instance T162_t0 r0 *1 0,0
RT162_t0 T162__t0 T162 0.0275
* device instance T162_t1 r0 *1 0,0
RT162_t1 T162__t1 T162 0.0275
* device instance T162 r0 *1 0,0
CT162 T162 vsubs 3.85855e-16
* device instance T163_t0 r0 *1 0,0
RT163_t0 T163__t0 T163 0.0275
* device instance T163_t1 r0 *1 0,0
RT163_t1 T163__t1 T163 0.0275
* device instance T163 r0 *1 0,0
CT163 T163 vsubs 3.85855e-16
* device instance T164_t0 r0 *1 0,0
RT164_t0 T164__t0 T164 0.0275
* device instance T164_t1 r0 *1 0,0
RT164_t1 T164__t1 T164 0.0275
* device instance T164 r0 *1 0,0
CT164 T164 vsubs 3.85855e-16
* device instance T165_t0 r0 *1 0,0
RT165_t0 T165__t0 T165 0.561
* device instance T165_t1 r0 *1 0,0
RT165_t1 T165__t1 T165 0.561
* device instance T165 r0 *1 0,0
CT165 T165 vsubs 5.3264e-16
* device instance T166_t0 r0 *1 0,0
RT166_t0 T166__t0 T166 0.0275
* device instance T166_t1 r0 *1 0,0
RT166_t1 T166__t1 T166 0.0275
* device instance T166 r0 *1 0,0
CT166 T166 vsubs 3.85855e-16
* device instance T167_t0 r0 *1 0,0
RT167_t0 T167__t0 T167 0.0275
* device instance T167_t1 r0 *1 0,0
RT167_t1 T167__t1 T167 0.0275
* device instance T167 r0 *1 0,0
CT167 T167 vsubs 3.85855e-16
* device instance T168_t0 r0 *1 0,0
RT168_t0 T168__t0 T168 0.0275
* device instance T168_t1 r0 *1 0,0
RT168_t1 T168__t1 T168 0.0275
* device instance T168 r0 *1 0,0
CT168 T168 vsubs 3.85855e-16
* device instance T169_t0 r0 *1 0,0
RT169_t0 T169__t0 T169 0.0275
* device instance T169_t1 r0 *1 0,0
RT169_t1 T169__t1 T169 0.0275
* device instance T169 r0 *1 0,0
CT169 T169 vsubs 3.85855e-16
* device instance T170_t0 r0 *1 0,0
RT170_t0 T170__t0 T170 0.0275
* device instance T170_t1 r0 *1 0,0
RT170_t1 T170__t1 T170 0.0275
* device instance T170 r0 *1 0,0
CT170 T170 vsubs 3.85855e-16
* device instance T171_t0 r0 *1 0,0
RT171_t0 T171__t0 T171 0.0275
* device instance T171_t1 r0 *1 0,0
RT171_t1 T171__t1 T171 0.0275
* device instance T171 r0 *1 0,0
CT171 T171 vsubs 3.85855e-16
* device instance T172_t0 r0 *1 0,0
RT172_t0 T172__t0 T172 0.0275
* device instance T172_t1 r0 *1 0,0
RT172_t1 T172__t1 T172 0.0275
* device instance T172 r0 *1 0,0
CT172 T172 vsubs 3.85855e-16
* device instance T173_t0 r0 *1 0,0
RT173_t0 T173__t0 T173 0.0275
* device instance T173_t1 r0 *1 0,0
RT173_t1 T173__t1 T173 0.0275
* device instance T173 r0 *1 0,0
CT173 T173 vsubs 3.85855e-16
* device instance T174_t0 r0 *1 0,0
RT174_t0 T174__t0 T174 0.0275
* device instance T174_t1 r0 *1 0,0
RT174_t1 T174__t1 T174 0.0275
* device instance T174 r0 *1 0,0
CT174 T174 vsubs 3.85855e-16
* device instance T175_t0 r0 *1 0,0
RT175_t0 T175__t0 T175 0.0275
* device instance T175_t1 r0 *1 0,0
RT175_t1 T175__t1 T175 0.0275
* device instance T175 r0 *1 0,0
CT175 T175 vsubs 3.85855e-16
* device instance T176_t0 r0 *1 0,0
RT176_t0 T176__t0 T176 0.0275
* device instance T176_t1 r0 *1 0,0
RT176_t1 T176__t1 T176 0.0275
* device instance T176 r0 *1 0,0
CT176 T176 vsubs 3.85855e-16
* device instance T177_t0 r0 *1 0,0
RT177_t0 T177__t0 T177 0.0275
* device instance T177_t1 r0 *1 0,0
RT177_t1 T177__t1 T177 0.0275
* device instance T177 r0 *1 0,0
CT177 T177 vsubs 3.85855e-16
* device instance T178_t0 r0 *1 0,0
RT178_t0 T178__t0 T178 0.0275
* device instance T178_t1 r0 *1 0,0
RT178_t1 T178__t1 T178 0.0275
* device instance T178 r0 *1 0,0
CT178 T178 vsubs 3.85855e-16
* device instance T179_t0 r0 *1 0,0
RT179_t0 T179__t0 T179 0.0275
* device instance T179_t1 r0 *1 0,0
RT179_t1 T179__t1 T179 0.0275
* device instance T179 r0 *1 0,0
CT179 T179 vsubs 3.85855e-16
* device instance T180_t0 r0 *1 0,0
RT180_t0 T180__t0 T180 0.561
* device instance T180_t1 r0 *1 0,0
RT180_t1 T180__t1 T180 0.561
* device instance T180 r0 *1 0,0
CT180 T180 vsubs 5.3264e-16
* device instance T181_t0 r0 *1 0,0
RT181_t0 T181__t0 T181 0.0275
* device instance T181_t1 r0 *1 0,0
RT181_t1 T181__t1 T181 0.0275
* device instance T181 r0 *1 0,0
CT181 T181 vsubs 3.85855e-16
* device instance T182_t0 r0 *1 0,0
RT182_t0 T182__t0 T182 0.0275
* device instance T182_t1 r0 *1 0,0
RT182_t1 T182__t1 T182 0.0275
* device instance T182 r0 *1 0,0
CT182 T182 vsubs 3.85855e-16
* device instance T183_t0 r0 *1 0,0
RT183_t0 T183__t0 T183 0.0275
* device instance T183_t1 r0 *1 0,0
RT183_t1 T183__t1 T183 0.0275
* device instance T183 r0 *1 0,0
CT183 T183 vsubs 3.85855e-16
* device instance T184_t0 r0 *1 0,0
RT184_t0 T184__t0 T184 0.0275
* device instance T184_t1 r0 *1 0,0
RT184_t1 T184__t1 T184 0.0275
* device instance T184 r0 *1 0,0
CT184 T184 vsubs 3.85855e-16
* device instance T185_t0 r0 *1 0,0
RT185_t0 T185__t0 T185 0.0275
* device instance T185_t1 r0 *1 0,0
RT185_t1 T185__t1 T185 0.0275
* device instance T185 r0 *1 0,0
CT185 T185 vsubs 3.85855e-16
* device instance T186_t0 r0 *1 0,0
RT186_t0 T186__t0 T186 0.0275
* device instance T186_t1 r0 *1 0,0
RT186_t1 T186__t1 T186 0.0275
* device instance T186 r0 *1 0,0
CT186 T186 vsubs 3.85855e-16
* device instance T187_t0 r0 *1 0,0
RT187_t0 T187__t0 T187 0.0275
* device instance T187_t1 r0 *1 0,0
RT187_t1 T187__t1 T187 0.0275
* device instance T187 r0 *1 0,0
CT187 T187 vsubs 3.85855e-16
* device instance T188_t0 r0 *1 0,0
RT188_t0 T188__t0 T188 0.0275
* device instance T188_t1 r0 *1 0,0
RT188_t1 T188__t1 T188 0.0275
* device instance T188 r0 *1 0,0
CT188 T188 vsubs 3.85855e-16
* device instance T189_t0 r0 *1 0,0
RT189_t0 T189__t0 T189 0.0275
* device instance T189_t1 r0 *1 0,0
RT189_t1 T189__t1 T189 0.0275
* device instance T189 r0 *1 0,0
CT189 T189 vsubs 3.85855e-16
* device instance T190_t0 r0 *1 0,0
RT190_t0 T190__t0 T190 0.0275
* device instance T190_t1 r0 *1 0,0
RT190_t1 T190__t1 T190 0.0275
* device instance T190 r0 *1 0,0
CT190 T190 vsubs 3.85855e-16
* device instance T191_t0 r0 *1 0,0
RT191_t0 T191__t0 T191 0.0275
* device instance T191_t1 r0 *1 0,0
RT191_t1 T191__t1 T191 0.0275
* device instance T191 r0 *1 0,0
CT191 T191 vsubs 3.85855e-16
* device instance T192_t0 r0 *1 0,0
RT192_t0 T192__t0 T192 0.0275
* device instance T192_t1 r0 *1 0,0
RT192_t1 T192__t1 T192 0.0275
* device instance T192 r0 *1 0,0
CT192 T192 vsubs 3.85855e-16
* device instance T193_t0 r0 *1 0,0
RT193_t0 T193__t0 T193 0.0275
* device instance T193_t1 r0 *1 0,0
RT193_t1 T193__t1 T193 0.0275
* device instance T193 r0 *1 0,0
CT193 T193 vsubs 3.85855e-16
* device instance T194_t0 r0 *1 0,0
RT194_t0 T194__t0 T194 0.0275
* device instance T194_t1 r0 *1 0,0
RT194_t1 T194__t1 T194 0.0275
* device instance T194 r0 *1 0,0
CT194 T194 vsubs 3.85855e-16
* device instance T195_t0 r0 *1 0,0
RT195_t0 T195__t0 T195 0.561
* device instance T195_t1 r0 *1 0,0
RT195_t1 T195__t1 T195 0.561
* device instance T195 r0 *1 0,0
CT195 T195 vsubs 5.3264e-16
* device instance T196_t0 r0 *1 0,0
RT196_t0 T196__t0 T196 0.0275
* device instance T196_t1 r0 *1 0,0
RT196_t1 T196__t1 T196 0.0275
* device instance T196 r0 *1 0,0
CT196 T196 vsubs 3.85855e-16
* device instance T197_t0 r0 *1 0,0
RT197_t0 T197__t0 T197 0.0275
* device instance T197_t1 r0 *1 0,0
RT197_t1 T197__t1 T197 0.0275
* device instance T197 r0 *1 0,0
CT197 T197 vsubs 3.85855e-16
* device instance T198_t0 r0 *1 0,0
RT198_t0 T198__t0 T198 0.0275
* device instance T198_t1 r0 *1 0,0
RT198_t1 T198__t1 T198 0.0275
* device instance T198 r0 *1 0,0
CT198 T198 vsubs 3.85855e-16
* device instance T199_t0 r0 *1 0,0
RT199_t0 T199__t0 T199 0.0275
* device instance T199_t1 r0 *1 0,0
RT199_t1 T199__t1 T199 0.0275
* device instance T199 r0 *1 0,0
CT199 T199 vsubs 3.85855e-16
* device instance T200_t0 r0 *1 0,0
RT200_t0 T200__t0 T200 0.0275
* device instance T200_t1 r0 *1 0,0
RT200_t1 T200__t1 T200 0.0275
* device instance T200 r0 *1 0,0
CT200 T200 vsubs 3.85855e-16
* device instance T201_t0 r0 *1 0,0
RT201_t0 T201__t0 T201 0.0275
* device instance T201_t1 r0 *1 0,0
RT201_t1 T201__t1 T201 0.0275
* device instance T201 r0 *1 0,0
CT201 T201 vsubs 3.85855e-16
* device instance T202_t0 r0 *1 0,0
RT202_t0 T202__t0 T202 0.0275
* device instance T202_t1 r0 *1 0,0
RT202_t1 T202__t1 T202 0.0275
* device instance T202 r0 *1 0,0
CT202 T202 vsubs 3.85855e-16
* device instance T203_t0 r0 *1 0,0
RT203_t0 T203__t0 T203 0.0275
* device instance T203_t1 r0 *1 0,0
RT203_t1 T203__t1 T203 0.0275
* device instance T203 r0 *1 0,0
CT203 T203 vsubs 3.85855e-16
* device instance T204_t0 r0 *1 0,0
RT204_t0 T204__t0 T204 0.0275
* device instance T204_t1 r0 *1 0,0
RT204_t1 T204__t1 T204 0.0275
* device instance T204 r0 *1 0,0
CT204 T204 vsubs 3.85855e-16
* device instance T205_t0 r0 *1 0,0
RT205_t0 T205__t0 T205 0.0275
* device instance T205_t1 r0 *1 0,0
RT205_t1 T205__t1 T205 0.0275
* device instance T205 r0 *1 0,0
CT205 T205 vsubs 3.85855e-16
* device instance T206_t0 r0 *1 0,0
RT206_t0 T206__t0 T206 0.0275
* device instance T206_t1 r0 *1 0,0
RT206_t1 T206__t1 T206 0.0275
* device instance T206 r0 *1 0,0
CT206 T206 vsubs 3.85855e-16
* device instance T207_t0 r0 *1 0,0
RT207_t0 T207__t0 T207 0.0275
* device instance T207_t1 r0 *1 0,0
RT207_t1 T207__t1 T207 0.0275
* device instance T207 r0 *1 0,0
CT207 T207 vsubs 3.85855e-16
* device instance T208_t0 r0 *1 0,0
RT208_t0 T208__t0 T208 0.0275
* device instance T208_t1 r0 *1 0,0
RT208_t1 T208__t1 T208 0.0275
* device instance T208 r0 *1 0,0
CT208 T208 vsubs 3.85855e-16
* device instance T209_t0 r0 *1 0,0
RT209_t0 T209__t0 T209 0.0275
* device instance T209_t1 r0 *1 0,0
RT209_t1 T209__t1 T209 0.0275
* device instance T209 r0 *1 0,0
CT209 T209 vsubs 3.85855e-16
* device instance T210_t0 r0 *1 0,0
RT210_t0 T210__t0 T210 0.561
* device instance T210_t1 r0 *1 0,0
RT210_t1 T210__t1 T210 0.561
* device instance T210 r0 *1 0,0
CT210 T210 vsubs 5.3264e-16
* device instance T211_t0 r0 *1 0,0
RT211_t0 T211__t0 T211 0.0275
* device instance T211_t1 r0 *1 0,0
RT211_t1 T211__t1 T211 0.0275
* device instance T211 r0 *1 0,0
CT211 T211 vsubs 3.85855e-16
* device instance T212_t0 r0 *1 0,0
RT212_t0 T212__t0 T212 0.0275
* device instance T212_t1 r0 *1 0,0
RT212_t1 T212__t1 T212 0.0275
* device instance T212 r0 *1 0,0
CT212 T212 vsubs 3.85855e-16
* device instance T213_t0 r0 *1 0,0
RT213_t0 T213__t0 T213 0.0275
* device instance T213_t1 r0 *1 0,0
RT213_t1 T213__t1 T213 0.0275
* device instance T213 r0 *1 0,0
CT213 T213 vsubs 3.85855e-16
* device instance T214_t0 r0 *1 0,0
RT214_t0 T214__t0 T214 0.0275
* device instance T214_t1 r0 *1 0,0
RT214_t1 T214__t1 T214 0.0275
* device instance T214 r0 *1 0,0
CT214 T214 vsubs 3.85855e-16
* device instance T215_t0 r0 *1 0,0
RT215_t0 T215__t0 T215 0.0275
* device instance T215_t1 r0 *1 0,0
RT215_t1 T215__t1 T215 0.0275
* device instance T215 r0 *1 0,0
CT215 T215 vsubs 3.85855e-16
* device instance T216_t0 r0 *1 0,0
RT216_t0 T216__t0 T216 0.0275
* device instance T216_t1 r0 *1 0,0
RT216_t1 T216__t1 T216 0.0275
* device instance T216 r0 *1 0,0
CT216 T216 vsubs 3.85855e-16
* device instance T217_t0 r0 *1 0,0
RT217_t0 T217__t0 T217 0.0275
* device instance T217_t1 r0 *1 0,0
RT217_t1 T217__t1 T217 0.0275
* device instance T217 r0 *1 0,0
CT217 T217 vsubs 3.85855e-16
* device instance T218_t0 r0 *1 0,0
RT218_t0 T218__t0 T218 0.0275
* device instance T218_t1 r0 *1 0,0
RT218_t1 T218__t1 T218 0.0275
* device instance T218 r0 *1 0,0
CT218 T218 vsubs 3.85855e-16
* device instance T219_t0 r0 *1 0,0
RT219_t0 T219__t0 T219 0.0275
* device instance T219_t1 r0 *1 0,0
RT219_t1 T219__t1 T219 0.0275
* device instance T219 r0 *1 0,0
CT219 T219 vsubs 3.85855e-16
* device instance T220_t0 r0 *1 0,0
RT220_t0 T220__t0 T220 0.0275
* device instance T220_t1 r0 *1 0,0
RT220_t1 T220__t1 T220 0.0275
* device instance T220 r0 *1 0,0
CT220 T220 vsubs 3.85855e-16
* device instance T221_t0 r0 *1 0,0
RT221_t0 T221__t0 T221 0.0275
* device instance T221_t1 r0 *1 0,0
RT221_t1 T221__t1 T221 0.0275
* device instance T221 r0 *1 0,0
CT221 T221 vsubs 3.85855e-16
* device instance T222_t0 r0 *1 0,0
RT222_t0 T222__t0 T222 0.0275
* device instance T222_t1 r0 *1 0,0
RT222_t1 T222__t1 T222 0.0275
* device instance T222 r0 *1 0,0
CT222 T222 vsubs 3.85855e-16
* device instance T223_t0 r0 *1 0,0
RT223_t0 T223__t0 T223 0.0275
* device instance T223_t1 r0 *1 0,0
RT223_t1 T223__t1 T223 0.0275
* device instance T223 r0 *1 0,0
CT223 T223 vsubs 3.85855e-16
* device instance T224_t0 r0 *1 0,0
RT224_t0 T224__t0 T224 0.0275
* device instance T224_t1 r0 *1 0,0
RT224_t1 T224__t1 T224 0.0275
* device instance T224 r0 *1 0,0
CT224 T224 vsubs 3.85855e-16
* device instance T225_t0 r0 *1 0,0
RT225_t0 T225__t0 T225 0.561
* device instance T225_t1 r0 *1 0,0
RT225_t1 T225__t1 T225 0.561
* device instance T225 r0 *1 0,0
CT225 T225 vsubs 5.3264e-16
* device instance T226_t0 r0 *1 0,0
RT226_t0 T226__t0 T226 0.0275
* device instance T226_t1 r0 *1 0,0
RT226_t1 T226__t1 T226 0.0275
* device instance T226 r0 *1 0,0
CT226 T226 vsubs 3.85855e-16
* device instance T227_t0 r0 *1 0,0
RT227_t0 T227__t0 T227 0.0275
* device instance T227_t1 r0 *1 0,0
RT227_t1 T227__t1 T227 0.0275
* device instance T227 r0 *1 0,0
CT227 T227 vsubs 3.85855e-16
* device instance T228_t0 r0 *1 0,0
RT228_t0 T228__t0 T228 0.0275
* device instance T228_t1 r0 *1 0,0
RT228_t1 T228__t1 T228 0.0275
* device instance T228 r0 *1 0,0
CT228 T228 vsubs 3.85855e-16
* device instance T229_t0 r0 *1 0,0
RT229_t0 T229__t0 T229 0.0275
* device instance T229_t1 r0 *1 0,0
RT229_t1 T229__t1 T229 0.0275
* device instance T229 r0 *1 0,0
CT229 T229 vsubs 3.85855e-16
* device instance T230_t0 r0 *1 0,0
RT230_t0 T230__t0 T230 0.0275
* device instance T230_t1 r0 *1 0,0
RT230_t1 T230__t1 T230 0.0275
* device instance T230 r0 *1 0,0
CT230 T230 vsubs 3.85855e-16
* device instance T231_t0 r0 *1 0,0
RT231_t0 T231__t0 T231 0.0275
* device instance T231_t1 r0 *1 0,0
RT231_t1 T231__t1 T231 0.0275
* device instance T231 r0 *1 0,0
CT231 T231 vsubs 3.85855e-16
* device instance T232_t0 r0 *1 0,0
RT232_t0 T232__t0 T232 0.0275
* device instance T232_t1 r0 *1 0,0
RT232_t1 T232__t1 T232 0.0275
* device instance T232 r0 *1 0,0
CT232 T232 vsubs 3.85855e-16
* device instance T233_t0 r0 *1 0,0
RT233_t0 T233__t0 T233 0.0275
* device instance T233_t1 r0 *1 0,0
RT233_t1 T233__t1 T233 0.0275
* device instance T233 r0 *1 0,0
CT233 T233 vsubs 3.85855e-16
* device instance T234_t0 r0 *1 0,0
RT234_t0 T234__t0 T234 0.0275
* device instance T234_t1 r0 *1 0,0
RT234_t1 T234__t1 T234 0.0275
* device instance T234 r0 *1 0,0
CT234 T234 vsubs 3.85855e-16
* device instance T235_t0 r0 *1 0,0
RT235_t0 T235__t0 T235 0.0275
* device instance T235_t1 r0 *1 0,0
RT235_t1 T235__t1 T235 0.0275
* device instance T235 r0 *1 0,0
CT235 T235 vsubs 3.85855e-16
* device instance T236_t0 r0 *1 0,0
RT236_t0 T236__t0 T236 0.0275
* device instance T236_t1 r0 *1 0,0
RT236_t1 T236__t1 T236 0.0275
* device instance T236 r0 *1 0,0
CT236 T236 vsubs 3.85855e-16
* device instance T237_t0 r0 *1 0,0
RT237_t0 T237__t0 T237 0.0275
* device instance T237_t1 r0 *1 0,0
RT237_t1 T237__t1 T237 0.0275
* device instance T237 r0 *1 0,0
CT237 T237 vsubs 3.85855e-16
* device instance T238_t0 r0 *1 0,0
RT238_t0 T238__t0 T238 0.0275
* device instance T238_t1 r0 *1 0,0
RT238_t1 T238__t1 T238 0.0275
* device instance T238 r0 *1 0,0
CT238 T238 vsubs 3.85855e-16
* device instance T239_t0 r0 *1 0,0
RT239_t0 T239__t0 T239 0.0275
* device instance T239_t1 r0 *1 0,0
RT239_t1 T239__t1 T239 0.0275
* device instance T239 r0 *1 0,0
CT239 T239 vsubs 3.85855e-16
* device instance T240_t0 r0 *1 0,0
RT240_t0 T240__t0 T240 0.561
* device instance T240_t1 r0 *1 0,0
RT240_t1 T240__t1 T240 0.561
* device instance T240 r0 *1 0,0
CT240 T240 vsubs 5.3264e-16
* device instance T241_t0 r0 *1 0,0
RT241_t0 T241__t0 T241 0.0275
* device instance T241_t1 r0 *1 0,0
RT241_t1 T241__t1 T241 0.0275
* device instance T241 r0 *1 0,0
CT241 T241 vsubs 3.85855e-16
* device instance T242_t0 r0 *1 0,0
RT242_t0 T242__t0 T242 0.0275
* device instance T242_t1 r0 *1 0,0
RT242_t1 T242__t1 T242 0.0275
* device instance T242 r0 *1 0,0
CT242 T242 vsubs 3.85855e-16
* device instance T243_t0 r0 *1 0,0
RT243_t0 T243__t0 T243 0.0275
* device instance T243_t1 r0 *1 0,0
RT243_t1 T243__t1 T243 0.0275
* device instance T243 r0 *1 0,0
CT243 T243 vsubs 3.85855e-16
* device instance T244_t0 r0 *1 0,0
RT244_t0 T244__t0 T244 0.0275
* device instance T244_t1 r0 *1 0,0
RT244_t1 T244__t1 T244 0.0275
* device instance T244 r0 *1 0,0
CT244 T244 vsubs 3.85855e-16
* device instance T245_t0 r0 *1 0,0
RT245_t0 T245__t0 T245 0.0275
* device instance T245_t1 r0 *1 0,0
RT245_t1 T245__t1 T245 0.0275
* device instance T245 r0 *1 0,0
CT245 T245 vsubs 3.85855e-16
* device instance T246_t0 r0 *1 0,0
RT246_t0 T246__t0 T246 0.0275
* device instance T246_t1 r0 *1 0,0
RT246_t1 T246__t1 T246 0.0275
* device instance T246 r0 *1 0,0
CT246 T246 vsubs 3.85855e-16
* device instance T247_t0 r0 *1 0,0
RT247_t0 T247__t0 T247 0.0275
* device instance T247_t1 r0 *1 0,0
RT247_t1 T247__t1 T247 0.0275
* device instance T247 r0 *1 0,0
CT247 T247 vsubs 3.85855e-16
* device instance T248_t0 r0 *1 0,0
RT248_t0 T248__t0 T248 0.0275
* device instance T248_t1 r0 *1 0,0
RT248_t1 T248__t1 T248 0.0275
* device instance T248 r0 *1 0,0
CT248 T248 vsubs 3.85855e-16
* device instance T249_t0 r0 *1 0,0
RT249_t0 T249__t0 T249 0.0275
* device instance T249_t1 r0 *1 0,0
RT249_t1 T249__t1 T249 0.0275
* device instance T249 r0 *1 0,0
CT249 T249 vsubs 3.85855e-16
* device instance T250_t0 r0 *1 0,0
RT250_t0 T250__t0 T250 0.0275
* device instance T250_t1 r0 *1 0,0
RT250_t1 T250__t1 T250 0.0275
* device instance T250 r0 *1 0,0
CT250 T250 vsubs 3.85855e-16
* device instance T251_t0 r0 *1 0,0
RT251_t0 T251__t0 T251 0.0275
* device instance T251_t1 r0 *1 0,0
RT251_t1 T251__t1 T251 0.0275
* device instance T251 r0 *1 0,0
CT251 T251 vsubs 3.85855e-16
* device instance T252_t0 r0 *1 0,0
RT252_t0 T252__t0 T252 0.0275
* device instance T252_t1 r0 *1 0,0
RT252_t1 T252__t1 T252 0.0275
* device instance T252 r0 *1 0,0
CT252 T252 vsubs 3.85855e-16
* device instance T253_t0 r0 *1 0,0
RT253_t0 T253__t0 T253 0.0275
* device instance T253_t1 r0 *1 0,0
RT253_t1 T253__t1 T253 0.0275
* device instance T253 r0 *1 0,0
CT253 T253 vsubs 3.85855e-16
* device instance T254_t0 r0 *1 0,0
RT254_t0 T254__t0 T254 0.0275
* device instance T254_t1 r0 *1 0,0
RT254_t1 T254__t1 T254 0.0275
* device instance T254 r0 *1 0,0
CT254 T254 vsubs 3.85855e-16
* device instance TAIL_t0 r0 *1 0,0
RTAIL_t0 TAIL__t0 TAIL 19.10445
* device instance TAIL_t1 r0 *1 0,0
RTAIL_t1 TAIL__t1 TAIL 19.10445
* device instance TAIL_t2 r0 *1 0,0
RTAIL_t2 TAIL__t2 TAIL 0.001
* device instance TAIL r0 *1 0,0
CTAIL TAIL vsubs 1.1348236e-14
* device instance VDD_t0 r0 *1 0,0
RVDD_t0 VDD__t0 VDD 18.6025153709
* device instance VDD_t1 r0 *1 0,0
RVDD_t1 VDD__t1 VDD 5.87856659789
* device instance VDD_t2 r0 *1 0,0
RVDD_t2 VDD__t2 VDD 5.87856659789
* device instance VDD_t3 r0 *1 0,0
RVDD_t3 VDD__t3 VDD 28.9180451036
* device instance VDD_t4 r0 *1 0,0
RVDD_t4 VDD__t4 VDD 9.39346589932
* device instance VDD_t5 r0 *1 0,0
RVDD_t5 VDD__t5 VDD 9.39346589932
* device instance VDD_t6 r0 *1 0,0
RVDD_t6 VDD__t6 VDD 7.21168320585
* device instance VDD_t7 r0 *1 0,0
RVDD_t7 VDD__t7 VDD 7.21168320585
* device instance VDD_t8 r0 *1 0,0
RVDD_t8 VDD__t8 VDD 5.38117681717
* device instance VDD_t9 r0 *1 0,0
RVDD_t9 VDD__t9 VDD 5.38117681717
* device instance VDD_t10 r0 *1 0,0
RVDD_t10 VDD__t10 VDD 9.59102603972
* device instance VDD_t11 r0 *1 0,0
RVDD_t11 VDD__t11 VDD 7.39915951263
* device instance VDD_t12 r0 *1 0,0
RVDD_t12 VDD__t12 VDD 9.59102603972
* device instance VDD_t13 r0 *1 0,0
RVDD_t13 VDD__t13 VDD 7.39915951263
* device instance VDD_t14 r0 *1 0,0
RVDD_t14 VDD__t14 VDD 18.0573914021
* device instance VDD_t15 r0 *1 0,0
RVDD_t15 VDD__t15 VDD 6.99580287112
* device instance VDD_t16 r0 *1 0,0
RVDD_t16 VDD__t16 VDD 11.6140315744
* device instance VDD_t17 r0 *1 0,0
RVDD_t17 VDD__t17 VDD 18.0573914021
* device instance VDD_t18 r0 *1 0,0
RVDD_t18 VDD__t18 VDD 6.99580287112
* device instance VDD_t19 r0 *1 0,0
RVDD_t19 VDD__t19 VDD 11.6140315744
* device instance VDD_t20 r0 *1 0,0
RVDD_t20 VDD__t20 VDD 11.2559316851
* device instance VDD r0 *1 0,0
CVDD VDD vsubs 5.5992567e-14
* device instance VREF_t0 r0 *1 0,0
RVREF_t0 VREF__t0 VREF 5.22771494039
* device instance VREF_t1 r0 *1 0,0
RVREF_t1 VREF__t1 VREF 7.94398451228
* device instance VREF_t2 r0 *1 0,0
RVREF_t2 VREF__t2 VREF 8.32710570991
* device instance VREF_t3 r0 *1 0,0
RVREF_t3 VREF__t3 VREF 2.64799483743
* device instance VREF r0 *1 0,0
CVREF VREF vsubs 7.999253e-15
* device instance VSS_t0 r0 *1 0,0
RVSS_t0 VSS__t0 VSS 4.58246082032
* device instance VSS_t1 r0 *1 0,0
RVSS_t1 VSS__t1 VSS 1.41958438338
* device instance VSS_t2 r0 *1 0,0
RVSS_t2 VSS__t2 VSS 1.86127399265
* device instance VSS_t3 r0 *1 0,0
RVSS_t3 VSS__t3 VSS 2.33650521879
* device instance VSS_t4 r0 *1 0,0
RVSS_t4 VSS__t4 VSS 3.71739458183
* device instance VSS_t5 r0 *1 0,0
RVSS_t5 VSS__t5 VSS 2.18556203357
* device instance VSS_t6 r0 *1 0,0
RVSS_t6 VSS__t6 VSS 0.896363631954
* device instance VSS_t7 r0 *1 0,0
RVSS_t7 VSS__t7 VSS 0.859758961392
* device instance VSS_t8 r0 *1 0,0
RVSS_t8 VSS__t8 VSS 0.827151544241
* device instance VSS_t9 r0 *1 0,0
RVSS_t9 VSS__t9 VSS 0.799030898669
* device instance VSS_t10 r0 *1 0,0
RVSS_t10 VSS__t10 VSS 0.775885024575
* device instance VSS_t11 r0 *1 0,0
RVSS_t11 VSS__t11 VSS 0.758169677666
* device instance VSS_t12 r0 *1 0,0
RVSS_t12 VSS__t12 VSS 0.746271695394
* device instance VSS_t13 r0 *1 0,0
RVSS_t13 VSS__t13 VSS 0.740471553135
* device instance VSS_t14 r0 *1 0,0
RVSS_t14 VSS__t14 VSS 0.740912473306
* device instance VSS_t15 r0 *1 0,0
RVSS_t15 VSS__t15 VSS 0.747583413166
* device instance VSS_t16 r0 *1 0,0
RVSS_t16 VSS__t16 VSS 0.760320406555
* device instance VSS_t17 r0 *1 0,0
RVSS_t17 VSS__t17 VSS 0.778825895851
* device instance VSS_t18 r0 *1 0,0
RVSS_t18 VSS__t18 VSS 0.802701019006
* device instance VSS_t19 r0 *1 0,0
RVSS_t19 VSS__t19 VSS 0.831483355349
* device instance VSS_t20 r0 *1 0,0
RVSS_t20 VSS__t20 VSS 0.864683010688
* device instance VSS_t21 r0 *1 0,0
RVSS_t21 VSS__t21 VSS 0.901812254388
* device instance VSS_t22 r0 *1 0,0
RVSS_t22 VSS__t22 VSS 0.94240674329
* device instance VSS_t23 r0 *1 0,0
RVSS_t23 VSS__t23 VSS 0.802675045153
* device instance VSS_t24 r0 *1 0,0
RVSS_t24 VSS__t24 VSS 0.761580553268
* device instance VSS_t25 r0 *1 0,0
RVSS_t25 VSS__t25 VSS 0.724568247001
* device instance VSS_t26 r0 *1 0,0
RVSS_t26 VSS__t26 VSS 0.692293178105
* device instance VSS_t27 r0 *1 0,0
RVSS_t27 VSS__t27 VSS 0.665444993055
* device instance VSS_t28 r0 *1 0,0
RVSS_t28 VSS__t28 VSS 0.644702045564
* device instance VSS_t29 r0 *1 0,0
RVSS_t29 VSS__t29 VSS 0.630667036374
* device instance VSS_t30 r0 *1 0,0
RVSS_t30 VSS__t30 VSS 0.623792905077
* device instance VSS_t31 r0 *1 0,0
RVSS_t31 VSS__t31 VSS 0.62431623439
* device instance VSS_t32 r0 *1 0,0
RVSS_t32 VSS__t32 VSS 0.632218654473
* device instance VSS_t33 r0 *1 0,0
RVSS_t33 VSS__t33 VSS 0.647229934448
* device instance VSS_t34 r0 *1 0,0
RVSS_t34 VSS__t34 VSS 0.668871619573
* device instance VSS_t35 r0 *1 0,0
RVSS_t35 VSS__t35 VSS 0.696525945917
* device instance VSS_t36 r0 *1 0,0
RVSS_t36 VSS__t36 VSS 0.729509450003
* device instance VSS_t37 r0 *1 0,0
RVSS_t37 VSS__t37 VSS 0.767135044431
* device instance VSS_t38 r0 *1 0,0
RVSS_t38 VSS__t38 VSS 0.808755098647
* device instance VSS_t39 r0 *1 0,0
RVSS_t39 VSS__t39 VSS 0.85378565063
* device instance VSS_t40 r0 *1 0,0
RVSS_t40 VSS__t40 VSS 0.71581077173
* device instance VSS_t41 r0 *1 0,0
RVSS_t41 VSS__t41 VSS 0.669404789294
* device instance VSS_t42 r0 *1 0,0
RVSS_t42 VSS__t42 VSS 0.626974463097
* device instance VSS_t43 r0 *1 0,0
RVSS_t43 VSS__t43 VSS 0.589379060762
* device instance VSS_t44 r0 *1 0,0
RVSS_t44 VSS__t44 VSS 0.557597409961
* device instance VSS_t45 r0 *1 0,0
RVSS_t45 VSS__t45 VSS 0.532671155937
* device instance VSS_t46 r0 *1 0,0
RVSS_t46 VSS__t46 VSS 0.515595523237
* device instance VSS_t47 r0 *1 0,0
RVSS_t47 VSS__t47 VSS 0.507164096953
* device instance VSS_t48 r0 *1 0,0
RVSS_t48 VSS__t48 VSS 0.507807634185
* device instance VSS_t49 r0 *1 0,0
RVSS_t49 VSS__t49 VSS 0.517492280017
* device instance VSS_t50 r0 *1 0,0
RVSS_t50 VSS__t50 VSS 0.535727935485
* device instance VSS_t51 r0 *1 0,0
RVSS_t51 VSS__t51 VSS 0.561682362447
* device instance VSS_t52 r0 *1 0,0
RVSS_t52 VSS__t52 VSS 0.594345207897
* device instance VSS_t53 r0 *1 0,0
RVSS_t53 VSS__t53 VSS 0.632678330954
* device instance VSS_t54 r0 *1 0,0
RVSS_t54 VSS__t54 VSS 0.675717403364
* device instance VSS_t55 r0 *1 0,0
RVSS_t55 VSS__t55 VSS 0.722622060555
* device instance VSS_t56 r0 *1 0,0
RVSS_t56 VSS__t56 VSS 0.772688663069
* device instance VSS_t57 r0 *1 0,0
RVSS_t57 VSS__t57 VSS 0.638561867896
* device instance VSS_t58 r0 *1 0,0
RVSS_t58 VSS__t58 VSS 0.586070789355
* device instance VSS_t59 r0 *1 0,0
RVSS_t59 VSS__t59 VSS 0.537096988989
* device instance VSS_t60 r0 *1 0,0
RVSS_t60 VSS__t60 VSS 0.492690445889
* device instance VSS_t61 r0 *1 0,0
RVSS_t61 VSS__t61 VSS 0.454192767226
* device instance VSS_t62 r0 *1 0,0
RVSS_t62 VSS__t62 VSS 0.423219515822
* device instance VSS_t63 r0 *1 0,0
RVSS_t63 VSS__t63 VSS 0.401515805152
* device instance VSS_t64 r0 *1 0,0
RVSS_t64 VSS__t64 VSS 0.390629772859
* device instance VSS_t65 r0 *1 0,0
RVSS_t65 VSS__t65 VSS 0.391464930156
* device instance VSS_t66 r0 *1 0,0
RVSS_t66 VSS__t66 VSS 0.403948583464
* device instance VSS_t67 r0 *1 0,0
RVSS_t67 VSS__t67 VSS 0.427060439592
* device instance VSS_t68 r0 *1 0,0
RVSS_t68 VSS__t68 VSS 0.459198513161
* device instance VSS_t69 r0 *1 0,0
RVSS_t69 VSS__t69 VSS 0.498620521394
* device instance VSS_t70 r0 *1 0,0
RVSS_t70 VSS__t70 VSS 0.543744488398
* device instance VSS_t71 r0 *1 0,0
RVSS_t71 VSS__t71 VSS 0.593270770739
* device instance VSS_t72 r0 *1 0,0
RVSS_t72 VSS__t72 VSS 0.64618792979
* device instance VSS_t73 r0 *1 0,0
RVSS_t73 VSS__t73 VSS 0.701729269904
* device instance VSS_t74 r0 *1 0,0
RVSS_t74 VSS__t74 VSS 0.57481807794
* device instance VSS_t75 r0 *1 0,0
RVSS_t75 VSS__t75 VSS 0.515881317486
* device instance VSS_t76 r0 *1 0,0
RVSS_t76 VSS__t76 VSS 0.459486386281
* device instance VSS_t77 r0 *1 0,0
RVSS_t77 VSS__t77 VSS 0.406692069097
* device instance VSS_t78 r0 *1 0,0
RVSS_t78 VSS__t78 VSS 0.359090007375
* device instance VSS_t79 r0 *1 0,0
RVSS_t79 VSS__t79 VSS 0.319013043886
* device instance VSS_t80 r0 *1 0,0
RVSS_t80 VSS__t80 VSS 0.289602322822
* device instance VSS_t81 r0 *1 0,0
RVSS_t81 VSS__t81 VSS 0.274310377201
* device instance VSS_t82 r0 *1 0,0
RVSS_t82 VSS__t82 VSS 0.275498375927
* device instance VSS_t83 r0 *1 0,0
RVSS_t83 VSS__t83 VSS 0.292965905318
* device instance VSS_t84 r0 *1 0,0
RVSS_t84 VSS__t84 VSS 0.324091318398
* device instance VSS_t85 r0 *1 0,0
RVSS_t85 VSS__t85 VSS 0.365400927866
* device instance VSS_t86 r0 *1 0,0
RVSS_t86 VSS__t86 VSS 0.413856240682
* device instance VSS_t87 r0 *1 0,0
RVSS_t87 VSS__t87 VSS 0.467239373619
* device instance VSS_t88 r0 *1 0,0
RVSS_t88 VSS__t88 VSS 0.524046535157
* device instance VSS_t89 r0 *1 0,0
RVSS_t89 VSS__t89 VSS 0.583278153373
* device instance VSS_t90 r0 *1 0,0
RVSS_t90 VSS__t90 VSS 0.644265885979
* device instance VSS_t91 r0 *1 0,0
RVSS_t91 VSS__t91 VSS 0.529479699058
* device instance VSS_t92 r0 *1 0,0
RVSS_t92 VSS__t92 VSS 0.464829498547
* device instance VSS_t93 r0 *1 0,0
RVSS_t93 VSS__t93 VSS 0.401323645162
* device instance VSS_t94 r0 *1 0,0
RVSS_t94 VSS__t94 VSS 0.339604723251
* device instance VSS_t95 r0 *1 0,0
RVSS_t95 VSS__t95 VSS 0.280853275546
* device instance VSS_t96 r0 *1 0,0
RVSS_t96 VSS__t96 VSS 0.227381290253
* device instance VSS_t97 r0 *1 0,0
RVSS_t97 VSS__t97 VSS 0.183854383607
* device instance VSS_t98 r0 *1 0,0
RVSS_t98 VSS__t98 VSS 0.158679274097
* device instance VSS_t99 r0 *1 0,0
RVSS_t99 VSS__t99 VSS 0.160724248719
* device instance VSS_t100 r0 *1 0,0
RVSS_t100 VSS__t100 VSS 0.189108304066
* device instance VSS_t101 r0 *1 0,0
RVSS_t101 VSS__t101 VSS 0.234452791941
* device instance VSS_t102 r0 *1 0,0
RVSS_t102 VSS__t102 VSS 0.288878464191
* device instance VSS_t103 r0 *1 0,0
RVSS_t103 VSS__t103 VSS 0.348152146251
* device instance VSS_t104 r0 *1 0,0
RVSS_t104 VSS__t104 VSS 0.410177475305
* device instance VSS_t105 r0 *1 0,0
RVSS_t105 VSS__t105 VSS 0.473875194537
* device instance VSS_t106 r0 *1 0,0
RVSS_t106 VSS__t106 VSS 0.538652330534
* device instance VSS_t107 r0 *1 0,0
RVSS_t107 VSS__t107 VSS 0.604161783651
* device instance VSS_t108 r0 *1 0,0
RVSS_t108 VSS__t108 VSS 0.50750373998
* device instance VSS_t109 r0 *1 0,0
RVSS_t109 VSS__t109 VSS 0.439633662381
* device instance VSS_t110 r0 *1 0,0
RVSS_t110 VSS__t110 VSS 0.371849381531
* device instance VSS_t111 r0 *1 0,0
RVSS_t111 VSS__t111 VSS 0.304208255038
* device instance VSS_t112 r0 *1 0,0
RVSS_t112 VSS__t112 VSS 0.236832972291
* device instance VSS_t113 r0 *1 0,0
RVSS_t113 VSS__t113 VSS 0.170039835146
* device instance VSS_t114 r0 *1 0,0
RVSS_t114 VSS__t114 VSS 0.10494631366
* device instance VSS_t115 r0 *1 0,0
RVSS_t115 VSS__t115 VSS 0.0488917826146
* device instance VSS_t116 r0 *1 0,0
RVSS_t116 VSS__t116 VSS 0.0551686369742
* device instance VSS_t117 r0 *1 0,0
RVSS_t117 VSS__t117 VSS 0.113900153845
* device instance VSS_t118 r0 *1 0,0
RVSS_t118 VSS__t118 VSS 0.179386192412
* device instance VSS_t119 r0 *1 0,0
RVSS_t119 VSS__t119 VSS 0.246296693954
* device instance VSS_t120 r0 *1 0,0
RVSS_t120 VSS__t120 VSS 0.313721550613
* device instance VSS_t121 r0 *1 0,0
RVSS_t121 VSS__t121 VSS 0.381388064348
* device instance VSS_t122 r0 *1 0,0
RVSS_t122 VSS__t122 VSS 0.449187037187
* device instance VSS_t123 r0 *1 0,0
RVSS_t123 VSS__t123 VSS 0.517066366697
* device instance VSS_t124 r0 *1 0,0
RVSS_t124 VSS__t124 VSS 0.584998081367
* device instance VSS_t125 r0 *1 0,0
RVSS_t125 VSS__t125 VSS 0.511907907601
* device instance VSS_t126 r0 *1 0,0
RVSS_t126 VSS__t126 VSS 0.444710486574
* device instance VSS_t127 r0 *1 0,0
RVSS_t127 VSS__t127 VSS 0.37783809008
* device instance VSS_t128 r0 *1 0,0
RVSS_t128 VSS__t128 VSS 0.311500115897
* device instance VSS_t129 r0 *1 0,0
RVSS_t129 VSS__t129 VSS 0.24612906479
* device instance VSS_t130 r0 *1 0,0
RVSS_t130 VSS__t130 VSS 0.182765437945
* device instance VSS_t131 r0 *1 0,0
RVSS_t131 VSS__t131 VSS 0.124512603866
* device instance VSS_t132 r0 *1 0,0
RVSS_t132 VSS__t132 VSS 0.0829461643349
* device instance VSS_t133 r0 *1 0,0
RVSS_t133 VSS__t133 VSS 0.08679422951
* device instance VSS_t134 r0 *1 0,0
RVSS_t134 VSS__t134 VSS 0.13214728456
* device instance VSS_t135 r0 *1 0,0
RVSS_t135 VSS__t135 VSS 0.191491685978
* device instance VSS_t136 r0 *1 0,0
RVSS_t136 VSS__t136 VSS 0.255248352048
* device instance VSS_t137 r0 *1 0,0
RVSS_t137 VSS__t137 VSS 0.320797242958
* device instance VSS_t138 r0 *1 0,0
RVSS_t138 VSS__t138 VSS 0.38722928014
* device instance VSS_t139 r0 *1 0,0
RVSS_t139 VSS__t139 VSS 0.454157080918
* device instance VSS_t140 r0 *1 0,0
RVSS_t140 VSS__t140 VSS 0.521389765281
* device instance VSS_t141 r0 *1 0,0
RVSS_t141 VSS__t141 VSS 0.588822906292
* device instance VSS_t142 r0 *1 0,0
RVSS_t142 VSS__t142 VSS 0.542049565101
* device instance VSS_t143 r0 *1 0,0
RVSS_t143 VSS__t143 VSS 0.479098572353
* device instance VSS_t144 r0 *1 0,0
RVSS_t144 VSS__t144 VSS 0.417767456221
* device instance VSS_t145 r0 *1 0,0
RVSS_t145 VSS__t145 VSS 0.358887652847
* device instance VSS_t146 r0 *1 0,0
RVSS_t146 VSS__t146 VSS 0.303887383247
* device instance VSS_t147 r0 *1 0,0
RVSS_t147 VSS__t147 VSS 0.255286565391
* device instance VSS_t148 r0 *1 0,0
RVSS_t148 VSS__t148 VSS 0.217419901765
* device instance VSS_t149 r0 *1 0,0
RVSS_t149 VSS__t149 VSS 0.196591178184
* device instance VSS_t150 r0 *1 0,0
RVSS_t150 VSS__t150 VSS 0.198245462592
* device instance VSS_t151 r0 *1 0,0
RVSS_t151 VSS__t151 VSS 0.22188044073
* device instance VSS_t152 r0 *1 0,0
RVSS_t152 VSS__t152 VSS 0.261604837419
* device instance VSS_t153 r0 *1 0,0
RVSS_t153 VSS__t153 VSS 0.311319363974
* device instance VSS_t154 r0 *1 0,0
RVSS_t154 VSS__t154 VSS 0.366986234417
* device instance VSS_t155 r0 *1 0,0
RVSS_t155 VSS__t155 VSS 0.426279885239
* device instance VSS_t156 r0 *1 0,0
RVSS_t156 VSS__t156 VSS 0.487879779566
* device instance VSS_t157 r0 *1 0,0
RVSS_t157 VSS__t157 VSS 0.551012987598
* device instance VSS_t158 r0 *1 0,0
RVSS_t158 VSS__t158 VSS 0.615207639855
* device instance VSS_t159 r0 *1 0,0
RVSS_t159 VSS__t159 VSS 0.594023670892
* device instance VSS_t160 r0 *1 0,0
RVSS_t160 VSS__t160 VSS 0.537198131591
* device instance VSS_t161 r0 *1 0,0
RVSS_t161 VSS__t161 VSS 0.483297049475
* device instance VSS_t162 r0 *1 0,0
RVSS_t162 VSS__t162 VSS 0.433412895424
* device instance VSS_t163 r0 *1 0,0
RVSS_t163 VSS__t163 VSS 0.389093731959
* device instance VSS_t164 r0 *1 0,0
RVSS_t164 VSS__t164 VSS 0.352445202865
* device instance VSS_t165 r0 *1 0,0
RVSS_t165 VSS__t165 VSS 0.326064110624
* device instance VSS_t166 r0 *1 0,0
RVSS_t166 VSS__t166 VSS 0.312561165043
* device instance VSS_t167 r0 *1 0,0
RVSS_t167 VSS__t167 VSS 0.313604295238
* device instance VSS_t168 r0 *1 0,0
RVSS_t168 VSS__t168 VSS 0.329055193747
* device instance VSS_t169 r0 *1 0,0
RVSS_t169 VSS__t169 VSS 0.357048290171
* device instance VSS_t170 r0 *1 0,0
RVSS_t170 VSS__t170 VSS 0.394925482767
* device instance VSS_t171 r0 *1 0,0
RVSS_t171 VSS__t171 VSS 0.440142348343
* device instance VSS_t172 r0 *1 0,0
RVSS_t172 VSS__t172 VSS 0.490673956017
* device instance VSS_t173 r0 *1 0,0
RVSS_t173 VSS__t173 VSS 0.545044099008
* device instance VSS_t174 r0 *1 0,0
RVSS_t174 VSS__t174 VSS 0.602214001046
* device instance VSS_t175 r0 *1 0,0
RVSS_t175 VSS__t175 VSS 0.66145810955
* device instance VSS_t176 r0 *1 0,0
RVSS_t176 VSS__t176 VSS 0.662713269465
* device instance VSS_t177 r0 *1 0,0
RVSS_t177 VSS__t177 VSS 0.612296160799
* device instance VSS_t178 r0 *1 0,0
RVSS_t178 VSS__t178 VSS 0.565597731587
* device instance VSS_t179 r0 *1 0,0
RVSS_t179 VSS__t179 VSS 0.523613878602
* device instance VSS_t180 r0 *1 0,0
RVSS_t180 VSS__t180 VSS 0.487564034969
* device instance VSS_t181 r0 *1 0,0
RVSS_t181 VSS__t181 VSS 0.45884896967
* device instance VSS_t182 r0 *1 0,0
RVSS_t182 VSS__t182 VSS 0.438910651707
* device instance VSS_t183 r0 *1 0,0
RVSS_t183 VSS__t183 VSS 0.428974635425
* device instance VSS_t184 r0 *1 0,0
RVSS_t184 VSS__t184 VSS 0.429735278906
* device instance VSS_t185 r0 *1 0,0
RVSS_t185 VSS__t185 VSS 0.441137253558
* device instance VSS_t186 r0 *1 0,0
RVSS_t186 VSS__t186 VSS 0.462394028356
* device instance VSS_t187 r0 *1 0,0
RVSS_t187 VSS__t187 VSS 0.492230528191
* device instance VSS_t188 r0 *1 0,0
RVSS_t188 VSS__t188 VSS 0.529197546054
* device instance VSS_t189 r0 *1 0,0
RVSS_t189 VSS__t189 VSS 0.571914055657
* device instance VSS_t190 r0 *1 0,0
RVSS_t190 VSS__t190 VSS 0.619191267548
* device instance VSS_t191 r0 *1 0,0
RVSS_t191 VSS__t191 VSS 0.670064518535
* device instance VSS_t192 r0 *1 0,0
RVSS_t192 VSS__t192 VSS 0.723775922945
* device instance VSS_t193 r0 *1 0,0
RVSS_t193 VSS__t193 VSS 0.74349983111
* device instance VSS_t194 r0 *1 0,0
RVSS_t194 VSS__t194 VSS 0.698934696424
* device instance VSS_t195 r0 *1 0,0
RVSS_t195 VSS__t195 VSS 0.65841014217
* device instance VSS_t196 r0 *1 0,0
RVSS_t196 VSS__t196 VSS 0.622715517071
* device instance VSS_t197 r0 *1 0,0
RVSS_t197 VSS__t197 VSS 0.592724058505
* device instance VSS_t198 r0 *1 0,0
RVSS_t198 VSS__t198 VSS 0.569337771717
* device instance VSS_t199 r0 *1 0,0
RVSS_t199 VSS__t199 VSS 0.553394688733
* device instance VSS_t200 r0 *1 0,0
RVSS_t200 VSS__t200 VSS 0.545547760672
* device instance VSS_t201 r0 *1 0,0
RVSS_t201 VSS__t201 VSS 0.54614607137
* device instance VSS_t202 r0 *1 0,0
RVSS_t202 VSS__t202 VSS 0.555162316636
* device instance VSS_t203 r0 *1 0,0
RVSS_t203 VSS__t203 VSS 0.572198705692
* device instance VSS_t204 r0 *1 0,0
RVSS_t204 VSS__t204 VSS 0.59656853271
* device instance VSS_t205 r0 *1 0,0
RVSS_t205 VSS__t205 VSS 0.627417854452
* device instance VSS_t206 r0 *1 0,0
RVSS_t206 VSS__t206 VSS 0.663843963891
* device instance VSS_t207 r0 *1 0,0
RVSS_t207 VSS__t207 VSS 0.704982941031
* device instance VSS_t208 r0 *1 0,0
RVSS_t208 VSS__t208 VSS 0.750059717847
* device instance VSS_t209 r0 *1 0,0
RVSS_t209 VSS__t209 VSS 0.798407607661
* device instance VSS_t210 r0 *1 0,0
RVSS_t210 VSS__t210 VSS 0.832870629563
* device instance VSS_t211 r0 *1 0,0
RVSS_t211 VSS__t211 VSS 0.793341790525
* device instance VSS_t212 r0 *1 0,0
RVSS_t212 VSS__t212 VSS 0.757882182163
* device instance VSS_t213 r0 *1 0,0
RVSS_t213 VSS__t213 VSS 0.727087410101
* device instance VSS_t214 r0 *1 0,0
RVSS_t214 VSS__t214 VSS 0.70157201787
* device instance VSS_t215 r0 *1 0,0
RVSS_t215 VSS__t215 VSS 0.681928870947
* device instance VSS_t216 r0 *1 0,0
RVSS_t216 VSS__t216 VSS 0.668675682409
* device instance VSS_t217 r0 *1 0,0
RVSS_t217 VSS__t217 VSS 0.662196229151
* device instance VSS_t218 r0 *1 0,0
RVSS_t218 VSS__t218 VSS 0.662689231843
* device instance VSS_t219 r0 *1 0,0
RVSS_t219 VSS__t219 VSS 0.67013930234
* device instance VSS_t220 r0 *1 0,0
RVSS_t220 VSS__t220 VSS 0.684319257016
* device instance VSS_t221 r0 *1 0,0
RVSS_t221 VSS__t221 VSS 0.704823028105
* device instance VSS_t222 r0 *1 0,0
RVSS_t222 VSS__t222 VSS 0.731118766558
* device instance VSS_t223 r0 *1 0,0
RVSS_t223 VSS__t223 VSS 0.762607562985
* device instance VSS_t224 r0 *1 0,0
RVSS_t224 VSS__t224 VSS 0.798675424607
* device instance VSS_t225 r0 *1 0,0
RVSS_t225 VSS__t225 VSS 0.838731820705
* device instance VSS_t226 r0 *1 0,0
RVSS_t226 VSS__t226 VSS 0.882233639518
* device instance VSS_t227 r0 *1 0,0
RVSS_t227 VSS__t227 VSS 0.928349792754
* device instance VSS_t228 r0 *1 0,0
RVSS_t228 VSS__t228 VSS 0.893057136309
* device instance VSS_t229 r0 *1 0,0
RVSS_t229 VSS__t229 VSS 0.861710655707
* device instance VSS_t230 r0 *1 0,0
RVSS_t230 VSS__t230 VSS 0.834755026368
* device instance VSS_t231 r0 *1 0,0
RVSS_t231 VSS__t231 VSS 0.812627312104
* device instance VSS_t232 r0 *1 0,0
RVSS_t232 VSS__t232 VSS 0.795730379683
* device instance VSS_t233 r0 *1 0,0
RVSS_t233 VSS__t233 VSS 0.784402333222
* device instance VSS_t234 r0 *1 0,0
RVSS_t234 VSS__t234 VSS 0.778886190673
* device instance VSS_t235 r0 *1 0,0
RVSS_t235 VSS__t235 VSS 0.779305376678
* device instance VSS_t236 r0 *1 0,0
RVSS_t236 VSS__t236 VSS 0.78565039086
* device instance VSS_t237 r0 *1 0,0
RVSS_t237 VSS__t237 VSS 0.797779855375
* device instance VSS_t238 r0 *1 0,0
RVSS_t238 VSS__t238 VSS 0.815435682973
* device instance VSS_t239 r0 *1 0,0
RVSS_t239 VSS__t239 VSS 0.838268753403
* device instance VSS_t240 r0 *1 0,0
RVSS_t240 VSS__t240 VSS 0.865869590204
* device instance VSS_t241 r0 *1 0,0
RVSS_t241 VSS__t241 VSS 0.897798577628
* device instance VSS_t242 r0 *1 0,0
RVSS_t242 VSS__t242 VSS 0.933611760414
* device instance VSS_t243 r0 *1 0,0
RVSS_t243 VSS__t243 VSS 0.972880283908
* device instance VSS_t244 r0 *1 0,0
RVSS_t244 VSS__t244 VSS 1.02823711041
* device instance VSS_t245 r0 *1 0,0
RVSS_t245 VSS__t245 VSS 0.996488467681
* device instance VSS_t246 r0 *1 0,0
RVSS_t246 VSS__t246 VSS 0.968495468068
* device instance VSS_t247 r0 *1 0,0
RVSS_t247 VSS__t247 VSS 0.944592066215
* device instance VSS_t248 r0 *1 0,0
RVSS_t248 VSS__t248 VSS 0.925095328
* device instance VSS_t249 r0 *1 0,0
RVSS_t249 VSS__t249 VSS 0.910288445857
* device instance VSS_t250 r0 *1 0,0
RVSS_t250 VSS__t250 VSS 0.900402819784
* device instance VSS_t251 r0 *1 0,0
RVSS_t251 VSS__t251 VSS 0.895601426713
* device instance VSS_t252 r0 *1 0,0
RVSS_t252 VSS__t252 VSS 0.895966008077
* device instance VSS_t253 r0 *1 0,0
RVSS_t253 VSS__t253 VSS 0.901490296215
* device instance VSS_t254 r0 *1 0,0
RVSS_t254 VSS__t254 VSS 0.912080542031
* device instance VSS_t255 r0 *1 0,0
RVSS_t255 VSS__t255 VSS 0.927563243437
* device instance VSS_t256 r0 *1 0,0
RVSS_t256 VSS__t256 VSS 0.947698644318
* device instance VSS_t257 r0 *1 0,0
RVSS_t257 VSS__t257 VSS 0.972197698388
* device instance VSS_t258 r0 *1 0,0
RVSS_t258 VSS__t258 VSS 1.00073997797
* device instance VSS_t259 r0 *1 0,0
RVSS_t259 VSS__t259 VSS 1.03299038558
* device instance VSS_t260 r0 *1 0,0
RVSS_t260 VSS__t260 VSS 1.06861324357
* device instance VSS_t261 r0 *1 0,0
RVSS_t261 VSS__t261 VSS 2.83711346119
* device instance VSS_t262 r0 *1 0,0
RVSS_t262 VSS__t262 VSS 1.30336908931
* device instance VSS_t263 r0 *1 0,0
RVSS_t263 VSS__t263 VSS 1.80192671213
* device instance VSS_t264 r0 *1 0,0
RVSS_t264 VSS__t264 VSS 4.58246082032
* device instance VSS_t265 r0 *1 0,0
RVSS_t265 VSS__t265 VSS 3.71739458183
* device instance VSS_t266 r0 *1 0,0
RVSS_t266 VSS__t266 VSS 2.18556203357
* device instance VSS_t267 r0 *1 0,0
RVSS_t267 VSS__t267 VSS 2.33650521879
* device instance VSS_t268 r0 *1 0,0
RVSS_t268 VSS__t268 VSS 1.41958438338
* device instance VSS_t269 r0 *1 0,0
RVSS_t269 VSS__t269 VSS 1.86127399265
* device instance VSS r0 *1 0,0
CVSS VSS vsubs 5.9622954e-14
* device instance cc_CB2_VDD r0 *1 0,0
Ccc_CB2_VDD CB2 VDD 8.235e-18
* device instance cc_CB2_VSS r0 *1 0,0
Ccc_CB2_VSS CB2 VSS 3.0251e-17
* device instance cc_CB3_T001_T003_T007_T015_T031_T063_T127_TN0 r0 *1 0,0
Ccc_CB3_T001_T003_T007_T015_T031_T063_T127_TN0 CB3
+ T001|T003|T007|T015|T031|T063|T127|TN0 1.1764e-17
* device instance cc_CB3_VDD r0 *1 0,0
Ccc_CB3_VDD CB3 VDD 8.235e-18
* device instance cc_CB3_VREF r0 *1 0,0
Ccc_CB3_VREF CB3 VREF 8.235e-18
* device instance cc_CB3_VSS r0 *1 0,0
Ccc_CB3_VSS CB3 VSS 2.0167e-17
* device instance cc_D1_D2 r0 *1 0,0
Ccc_D1_D2 D1 D2 1.4117e-17
* device instance cc_D1_VSS r0 *1 0,0
Ccc_D1_VSS D1 VSS 3.3411e-17
* device instance cc_D2_FB_OUT r0 *1 0,0
Ccc_D2_FB_OUT D2 FB|OUT 1.4117e-17
* device instance cc_DET_VDD r0 *1 0,0
Ccc_DET_VDD DET VDD 8.235e-18
* device instance cc_FB_OUT_IN_N_SNS1 r0 *1 0,0
Ccc_FB_OUT_IN_N_SNS1 FB|OUT IN_N|SNS1 2.1176e-17
* device instance cc_FB_OUT_PN r0 *1 0,0
Ccc_FB_OUT_PN FB|OUT PN 1.4117e-17
* device instance cc_FB_OUT_VDD r0 *1 0,0
Ccc_FB_OUT_VDD FB|OUT VDD 3.3485e-17
* device instance cc_FB_OUT_VSS r0 *1 0,0
Ccc_FB_OUT_VSS FB|OUT VSS 4.0543e-17
* device instance cc_IN_N_SNS1_IN_P_SNS2 r0 *1 0,0
Ccc_IN_N_SNS1_IN_P_SNS2 IN_N|SNS1 IN_P|SNS2 1.4117e-17
* device instance cc_IN_N_SNS1_TAIL r0 *1 0,0
Ccc_IN_N_SNS1_TAIL IN_N|SNS1 TAIL 7.059e-18
* device instance cc_IN_N_SNS1_VDD r0 *1 0,0
Ccc_IN_N_SNS1_VDD IN_N|SNS1 VDD 2.523e-17
* device instance cc_IN_N_SNS1_VSS r0 *1 0,0
Ccc_IN_N_SNS1_VSS IN_N|SNS1 VSS 4.4368e-17
* device instance cc_IN_P_SNS2_VDD r0 *1 0,0
Ccc_IN_P_SNS2_VDD IN_P|SNS2 VDD 2.2352e-17
* device instance cc_T001_T003_T007_T015_T031_T063_T127_TN0_T002 r0 *1 0,0
Ccc_T001_T003_T007_T015_T031_T063_T127_TN0_T002
+ T001|T003|T007|T015|T031|T063|T127|TN0 T002 8.067e-17
* device instance cc_T001_T003_T007_T015_T031_T063_T127_TN0_T004 r0 *1 0,0
Ccc_T001_T003_T007_T015_T031_T063_T127_TN0_T004
+ T001|T003|T007|T015|T031|T063|T127|TN0 T004 8.067e-17
* device instance cc_T001_T003_T007_T015_T031_T063_T127_TN0_T005 r0 *1 0,0
Ccc_T001_T003_T007_T015_T031_T063_T127_TN0_T005
+ T001|T003|T007|T015|T031|T063|T127|TN0 T005 8.067e-17
* device instance cc_T001_T003_T007_T015_T031_T063_T127_TN0_T006 r0 *1 0,0
Ccc_T001_T003_T007_T015_T031_T063_T127_TN0_T006
+ T001|T003|T007|T015|T031|T063|T127|TN0 T006 8.067e-17
* device instance cc_T001_T003_T007_T015_T031_T063_T127_TN0_T008 r0 *1 0,0
Ccc_T001_T003_T007_T015_T031_T063_T127_TN0_T008
+ T001|T003|T007|T015|T031|T063|T127|TN0 T008 8.067e-17
* device instance cc_T001_T003_T007_T015_T031_T063_T127_TN0_T009 r0 *1 0,0
Ccc_T001_T003_T007_T015_T031_T063_T127_TN0_T009
+ T001|T003|T007|T015|T031|T063|T127|TN0 T009 8.067e-17
* device instance cc_T001_T003_T007_T015_T031_T063_T127_TN0_T010 r0 *1 0,0
Ccc_T001_T003_T007_T015_T031_T063_T127_TN0_T010
+ T001|T003|T007|T015|T031|T063|T127|TN0 T010 8.067e-17
* device instance cc_T001_T003_T007_T015_T031_T063_T127_TN0_T011 r0 *1 0,0
Ccc_T001_T003_T007_T015_T031_T063_T127_TN0_T011
+ T001|T003|T007|T015|T031|T063|T127|TN0 T011 8.067e-17
* device instance cc_T001_T003_T007_T015_T031_T063_T127_TN0_T012 r0 *1 0,0
Ccc_T001_T003_T007_T015_T031_T063_T127_TN0_T012
+ T001|T003|T007|T015|T031|T063|T127|TN0 T012 8.067e-17
* device instance cc_T001_T003_T007_T015_T031_T063_T127_TN0_T013 r0 *1 0,0
Ccc_T001_T003_T007_T015_T031_T063_T127_TN0_T013
+ T001|T003|T007|T015|T031|T063|T127|TN0 T013 8.067e-17
* device instance cc_T001_T003_T007_T015_T031_T063_T127_TN0_T014 r0 *1 0,0
Ccc_T001_T003_T007_T015_T031_T063_T127_TN0_T014
+ T001|T003|T007|T015|T031|T063|T127|TN0 T014 8.067e-17
* device instance cc_T001_T003_T007_T015_T031_T063_T127_TN0_T032 r0 *1 0,0
Ccc_T001_T003_T007_T015_T031_T063_T127_TN0_T032
+ T001|T003|T007|T015|T031|T063|T127|TN0 T032 8.067e-17
* device instance cc_T001_T003_T007_T015_T031_T063_T127_TN0_T033 r0 *1 0,0
Ccc_T001_T003_T007_T015_T031_T063_T127_TN0_T033
+ T001|T003|T007|T015|T031|T063|T127|TN0 T033 8.067e-17
* device instance cc_T001_T003_T007_T015_T031_T063_T127_TN0_T034 r0 *1 0,0
Ccc_T001_T003_T007_T015_T031_T063_T127_TN0_T034
+ T001|T003|T007|T015|T031|T063|T127|TN0 T034 8.067e-17
* device instance cc_T001_T003_T007_T015_T031_T063_T127_TN0_T035 r0 *1 0,0
Ccc_T001_T003_T007_T015_T031_T063_T127_TN0_T035
+ T001|T003|T007|T015|T031|T063|T127|TN0 T035 8.067e-17
* device instance cc_T001_T003_T007_T015_T031_T063_T127_TN0_T036 r0 *1 0,0
Ccc_T001_T003_T007_T015_T031_T063_T127_TN0_T036
+ T001|T003|T007|T015|T031|T063|T127|TN0 T036 8.067e-17
* device instance cc_T001_T003_T007_T015_T031_T063_T127_TN0_T037 r0 *1 0,0
Ccc_T001_T003_T007_T015_T031_T063_T127_TN0_T037
+ T001|T003|T007|T015|T031|T063|T127|TN0 T037 8.067e-17
* device instance cc_T001_T003_T007_T015_T031_T063_T127_TN0_T038 r0 *1 0,0
Ccc_T001_T003_T007_T015_T031_T063_T127_TN0_T038
+ T001|T003|T007|T015|T031|T063|T127|TN0 T038 8.067e-17
* device instance cc_T001_T003_T007_T015_T031_T063_T127_TN0_T039 r0 *1 0,0
Ccc_T001_T003_T007_T015_T031_T063_T127_TN0_T039
+ T001|T003|T007|T015|T031|T063|T127|TN0 T039 8.067e-17
* device instance cc_T001_T003_T007_T015_T031_T063_T127_TN0_T040 r0 *1 0,0
Ccc_T001_T003_T007_T015_T031_T063_T127_TN0_T040
+ T001|T003|T007|T015|T031|T063|T127|TN0 T040 8.067e-17
* device instance cc_T001_T003_T007_T015_T031_T063_T127_TN0_T041 r0 *1 0,0
Ccc_T001_T003_T007_T015_T031_T063_T127_TN0_T041
+ T001|T003|T007|T015|T031|T063|T127|TN0 T041 8.067e-17
* device instance cc_T001_T003_T007_T015_T031_T063_T127_TN0_T042 r0 *1 0,0
Ccc_T001_T003_T007_T015_T031_T063_T127_TN0_T042
+ T001|T003|T007|T015|T031|T063|T127|TN0 T042 8.067e-17
* device instance cc_T001_T003_T007_T015_T031_T063_T127_TN0_T043 r0 *1 0,0
Ccc_T001_T003_T007_T015_T031_T063_T127_TN0_T043
+ T001|T003|T007|T015|T031|T063|T127|TN0 T043 8.067e-17
* device instance cc_T001_T003_T007_T015_T031_T063_T127_TN0_T044 r0 *1 0,0
Ccc_T001_T003_T007_T015_T031_T063_T127_TN0_T044
+ T001|T003|T007|T015|T031|T063|T127|TN0 T044 8.067e-17
* device instance cc_T001_T003_T007_T015_T031_T063_T127_TN0_T045 r0 *1 0,0
Ccc_T001_T003_T007_T015_T031_T063_T127_TN0_T045
+ T001|T003|T007|T015|T031|T063|T127|TN0 T045 4.8738e-17
* device instance cc_T001_T003_T007_T015_T031_T063_T127_TN0_T059 r0 *1 0,0
Ccc_T001_T003_T007_T015_T031_T063_T127_TN0_T059
+ T001|T003|T007|T015|T031|T063|T127|TN0 T059 1.21005e-16
* device instance cc_T001_T003_T007_T015_T031_T063_T127_TN0_T061 r0 *1 0,0
Ccc_T001_T003_T007_T015_T031_T063_T127_TN0_T061
+ T001|T003|T007|T015|T031|T063|T127|TN0 T061 1.0756e-16
* device instance cc_T001_T003_T007_T015_T031_T063_T127_TN0_T062 r0 *1 0,0
Ccc_T001_T003_T007_T015_T031_T063_T127_TN0_T062
+ T001|T003|T007|T015|T031|T063|T127|TN0 T062 8.067e-17
* device instance cc_T001_T003_T007_T015_T031_T063_T127_TN0_T087 r0 *1 0,0
Ccc_T001_T003_T007_T015_T031_T063_T127_TN0_T087
+ T001|T003|T007|T015|T031|T063|T127|TN0 T087 1.21005e-16
* device instance cc_T001_T003_T007_T015_T031_T063_T127_TN0_T093 r0 *1 0,0
Ccc_T001_T003_T007_T015_T031_T063_T127_TN0_T093
+ T001|T003|T007|T015|T031|T063|T127|TN0 T093 1.21005e-16
* device instance cc_T001_T003_T007_T015_T031_T063_T127_TN0_T117 r0 *1 0,0
Ccc_T001_T003_T007_T015_T031_T063_T127_TN0_T117
+ T001|T003|T007|T015|T031|T063|T127|TN0 T117 1.21005e-16
* device instance cc_T001_T003_T007_T015_T031_T063_T127_TN0_T123 r0 *1 0,0
Ccc_T001_T003_T007_T015_T031_T063_T127_TN0_T123
+ T001|T003|T007|T015|T031|T063|T127|TN0 T123 1.0756e-16
* device instance cc_T001_T003_T007_T015_T031_T063_T127_TN0_T124 r0 *1 0,0
Ccc_T001_T003_T007_T015_T031_T063_T127_TN0_T124
+ T001|T003|T007|T015|T031|T063|T127|TN0 T124 8.067e-17
* device instance cc_T001_T003_T007_T015_T031_T063_T127_TN0_T125 r0 *1 0,0
Ccc_T001_T003_T007_T015_T031_T063_T127_TN0_T125
+ T001|T003|T007|T015|T031|T063|T127|TN0 T125 8.067e-17
* device instance cc_T001_T003_T007_T015_T031_T063_T127_TN0_T126 r0 *1 0,0
Ccc_T001_T003_T007_T015_T031_T063_T127_TN0_T126
+ T001|T003|T007|T015|T031|T063|T127|TN0 T126 8.067e-17
* device instance cc_T001_T003_T007_T015_T031_T063_T127_TN0_VREF r0 *1 0,0
Ccc_T001_T003_T007_T015_T031_T063_T127_TN0_VREF
+ T001|T003|T007|T015|T031|T063|T127|TN0 VREF 1.1764e-17
* device instance cc_TAIL_VDD r0 *1 0,0
Ccc_TAIL_VDD TAIL VDD 2.7367e-17
* device instance cc_TAIL_VSS r0 *1 0,0
Ccc_TAIL_VSS TAIL VSS 8.235e-18
* device instance cc_VDD_VREF r0 *1 0,0
Ccc_VDD_VREF VDD VREF 1.4117e-17
* device instance cc_VDD_VSS r0 *1 0,0
Ccc_VDD_VSS VDD VSS 2.3381e-17
* device instance vsubs_dctie r0 *1 0,0
Rvsubs_dctie vsubs 0 1e+12
.ENDS bandgap_top
