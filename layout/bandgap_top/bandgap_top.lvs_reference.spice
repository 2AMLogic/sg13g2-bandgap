* Auto-generated by layout/lvs_reference.py's flatten() -- DO NOT EDIT BY HAND.
* Source: design/netlist/bandgap_top.spice (flattened)
* Plain-element form for `klt lvs`, expanded from a hierarchical
* top-level netlist whose own X-calls are subckt instantiations,
* not devices -- see flatten()'s own docstring.
Mx1_M1 IN_N,SNS1 FB,OUT vdd vdd pfet L=1U W=10U
Qx1_Q1 IN_N,SNS1 IN_N,SNS1 vss vss npn13g2
Mx1_M2A IN_P,SNS2 FB,OUT vdd vdd pfet L=1U W=9U
Mx1_M2B IN_P,SNS2 FB,OUT vdd vdd pfet L=1U W=1U
Rx1_R2 IN_P,SNS2 cb2 10753.843470 rppd L=82.7U W=2U
Qx1_Q2 cb2 cb2 vss vss npn13g2
Mx1_M3A vref FB,OUT vdd vdd pfet L=1U W=8U
Mx1_M3B vref FB,OUT vdd vdd pfet L=1U W=1U
Mx1_M3C vref FB,OUT vdd vdd pfet L=1U W=1U
Rx1_R1 vref T001,T003,T007,T015,T031,T063,T127,TN0 4856.535394 rppd L=37.2U W=2U
RU1 T001,T003,T007,T015,T031,T063,T127,TN0 T001,T003,T007,T015,T031,T063,T127,TN0 479.566301 rppd L=3.43U W=2U
RU2 T001,T003,T007,T015,T031,T063,T127,TN0 t002 479.566301 rppd L=3.43U W=2U
RU3 t002 T001,T003,T007,T015,T031,T063,T127,TN0 479.566301 rppd L=3.43U W=2U
RU4 T001,T003,T007,T015,T031,T063,T127,TN0 t004 479.566301 rppd L=3.43U W=2U
RU5 t004 t005 479.566301 rppd L=3.43U W=2U
RU6 t005 t006 479.566301 rppd L=3.43U W=2U
RU7 t006 T001,T003,T007,T015,T031,T063,T127,TN0 479.566301 rppd L=3.43U W=2U
RU8 T001,T003,T007,T015,T031,T063,T127,TN0 t008 479.566301 rppd L=3.43U W=2U
RU9 t008 t009 479.566301 rppd L=3.43U W=2U
RU10 t009 t010 479.566301 rppd L=3.43U W=2U
RU11 t010 t011 479.566301 rppd L=3.43U W=2U
RU12 t011 t012 479.566301 rppd L=3.43U W=2U
RU13 t012 t013 479.566301 rppd L=3.43U W=2U
RU14 t013 t014 479.566301 rppd L=3.43U W=2U
RU15 t014 T001,T003,T007,T015,T031,T063,T127,TN0 479.566301 rppd L=3.43U W=2U
RU16 T001,T003,T007,T015,T031,T063,T127,TN0 t016 479.566301 rppd L=3.43U W=2U
RU17 t016 t017 479.566301 rppd L=3.43U W=2U
RU18 t017 t018 479.566301 rppd L=3.43U W=2U
RU19 t018 t019 479.566301 rppd L=3.43U W=2U
RU20 t019 t020 479.566301 rppd L=3.43U W=2U
RU21 t020 t021 479.566301 rppd L=3.43U W=2U
RU22 t021 t022 479.566301 rppd L=3.43U W=2U
RU23 t022 t023 479.566301 rppd L=3.43U W=2U
RU24 t023 t024 479.566301 rppd L=3.43U W=2U
RU25 t024 t025 479.566301 rppd L=3.43U W=2U
RU26 t025 t026 479.566301 rppd L=3.43U W=2U
RU27 t026 t027 479.566301 rppd L=3.43U W=2U
RU28 t027 t028 479.566301 rppd L=3.43U W=2U
RU29 t028 t029 479.566301 rppd L=3.43U W=2U
RU30 t029 t030 479.566301 rppd L=3.43U W=2U
RU31 t030 T001,T003,T007,T015,T031,T063,T127,TN0 479.566301 rppd L=3.43U W=2U
RU32 T001,T003,T007,T015,T031,T063,T127,TN0 t032 479.566301 rppd L=3.43U W=2U
RU33 t032 t033 479.566301 rppd L=3.43U W=2U
RU34 t033 t034 479.566301 rppd L=3.43U W=2U
RU35 t034 t035 479.566301 rppd L=3.43U W=2U
RU36 t035 t036 479.566301 rppd L=3.43U W=2U
RU37 t036 t037 479.566301 rppd L=3.43U W=2U
RU38 t037 t038 479.566301 rppd L=3.43U W=2U
RU39 t038 t039 479.566301 rppd L=3.43U W=2U
RU40 t039 t040 479.566301 rppd L=3.43U W=2U
RU41 t040 t041 479.566301 rppd L=3.43U W=2U
RU42 t041 t042 479.566301 rppd L=3.43U W=2U
RU43 t042 t043 479.566301 rppd L=3.43U W=2U
RU44 t043 t044 479.566301 rppd L=3.43U W=2U
RU45 t044 t045 479.566301 rppd L=3.43U W=2U
RU46 t045 t046 479.566301 rppd L=3.43U W=2U
RU47 t046 t047 479.566301 rppd L=3.43U W=2U
RU48 t047 t048 479.566301 rppd L=3.43U W=2U
RU49 t048 t049 479.566301 rppd L=3.43U W=2U
RU50 t049 t050 479.566301 rppd L=3.43U W=2U
RU51 t050 t051 479.566301 rppd L=3.43U W=2U
RU52 t051 t052 479.566301 rppd L=3.43U W=2U
RU53 t052 t053 479.566301 rppd L=3.43U W=2U
RU54 t053 t054 479.566301 rppd L=3.43U W=2U
RU55 t054 t055 479.566301 rppd L=3.43U W=2U
RU56 t055 t056 479.566301 rppd L=3.43U W=2U
RU57 t056 t057 479.566301 rppd L=3.43U W=2U
RU58 t057 t058 479.566301 rppd L=3.43U W=2U
RU59 t058 t059 479.566301 rppd L=3.43U W=2U
RU60 t059 t060 479.566301 rppd L=3.43U W=2U
RU61 t060 t061 479.566301 rppd L=3.43U W=2U
RU62 t061 t062 479.566301 rppd L=3.43U W=2U
RU63 t062 T001,T003,T007,T015,T031,T063,T127,TN0 479.566301 rppd L=3.43U W=2U
RU64 T001,T003,T007,T015,T031,T063,T127,TN0 t064 479.566301 rppd L=3.43U W=2U
RU65 t064 t065 479.566301 rppd L=3.43U W=2U
RU66 t065 t066 479.566301 rppd L=3.43U W=2U
RU67 t066 t067 479.566301 rppd L=3.43U W=2U
RU68 t067 t068 479.566301 rppd L=3.43U W=2U
RU69 t068 t069 479.566301 rppd L=3.43U W=2U
RU70 t069 t070 479.566301 rppd L=3.43U W=2U
RU71 t070 t071 479.566301 rppd L=3.43U W=2U
RU72 t071 t072 479.566301 rppd L=3.43U W=2U
RU73 t072 t073 479.566301 rppd L=3.43U W=2U
RU74 t073 t074 479.566301 rppd L=3.43U W=2U
RU75 t074 t075 479.566301 rppd L=3.43U W=2U
RU76 t075 t076 479.566301 rppd L=3.43U W=2U
RU77 t076 t077 479.566301 rppd L=3.43U W=2U
RU78 t077 t078 479.566301 rppd L=3.43U W=2U
RU79 t078 t079 479.566301 rppd L=3.43U W=2U
RU80 t079 t080 479.566301 rppd L=3.43U W=2U
RU81 t080 t081 479.566301 rppd L=3.43U W=2U
RU82 t081 t082 479.566301 rppd L=3.43U W=2U
RU83 t082 t083 479.566301 rppd L=3.43U W=2U
RU84 t083 t084 479.566301 rppd L=3.43U W=2U
RU85 t084 t085 479.566301 rppd L=3.43U W=2U
RU86 t085 t086 479.566301 rppd L=3.43U W=2U
RU87 t086 t087 479.566301 rppd L=3.43U W=2U
RU88 t087 t088 479.566301 rppd L=3.43U W=2U
RU89 t088 t089 479.566301 rppd L=3.43U W=2U
RU90 t089 t090 479.566301 rppd L=3.43U W=2U
RU91 t090 t091 479.566301 rppd L=3.43U W=2U
RU92 t091 t092 479.566301 rppd L=3.43U W=2U
RU93 t092 t093 479.566301 rppd L=3.43U W=2U
RU94 t093 t094 479.566301 rppd L=3.43U W=2U
RU95 t094 t095 479.566301 rppd L=3.43U W=2U
RU96 t095 t096 479.566301 rppd L=3.43U W=2U
RU97 t096 t097 479.566301 rppd L=3.43U W=2U
RU98 t097 t098 479.566301 rppd L=3.43U W=2U
RU99 t098 t099 479.566301 rppd L=3.43U W=2U
RU100 t099 t100 479.566301 rppd L=3.43U W=2U
RU101 t100 t101 479.566301 rppd L=3.43U W=2U
RU102 t101 t102 479.566301 rppd L=3.43U W=2U
RU103 t102 t103 479.566301 rppd L=3.43U W=2U
RU104 t103 t104 479.566301 rppd L=3.43U W=2U
RU105 t104 t105 479.566301 rppd L=3.43U W=2U
RU106 t105 t106 479.566301 rppd L=3.43U W=2U
RU107 t106 t107 479.566301 rppd L=3.43U W=2U
RU108 t107 t108 479.566301 rppd L=3.43U W=2U
RU109 t108 t109 479.566301 rppd L=3.43U W=2U
RU110 t109 t110 479.566301 rppd L=3.43U W=2U
RU111 t110 t111 479.566301 rppd L=3.43U W=2U
RU112 t111 t112 479.566301 rppd L=3.43U W=2U
RU113 t112 t113 479.566301 rppd L=3.43U W=2U
RU114 t113 t114 479.566301 rppd L=3.43U W=2U
RU115 t114 t115 479.566301 rppd L=3.43U W=2U
RU116 t115 t116 479.566301 rppd L=3.43U W=2U
RU117 t116 t117 479.566301 rppd L=3.43U W=2U
RU118 t117 t118 479.566301 rppd L=3.43U W=2U
RU119 t118 t119 479.566301 rppd L=3.43U W=2U
RU120 t119 t120 479.566301 rppd L=3.43U W=2U
RU121 t120 t121 479.566301 rppd L=3.43U W=2U
RU122 t121 t122 479.566301 rppd L=3.43U W=2U
RU123 t122 t123 479.566301 rppd L=3.43U W=2U
RU124 t123 t124 479.566301 rppd L=3.43U W=2U
RU125 t124 t125 479.566301 rppd L=3.43U W=2U
RU126 t125 t126 479.566301 rppd L=3.43U W=2U
RU127 t126 T001,T003,T007,T015,T031,T063,T127,TN0 479.566301 rppd L=3.43U W=2U
RU128 T001,T003,T007,T015,T031,T063,T127,TN0 t128 479.566301 rppd L=3.43U W=2U
RU129 t128 t129 479.566301 rppd L=3.43U W=2U
RU130 t129 t130 479.566301 rppd L=3.43U W=2U
RU131 t130 t131 479.566301 rppd L=3.43U W=2U
RU132 t131 t132 479.566301 rppd L=3.43U W=2U
RU133 t132 t133 479.566301 rppd L=3.43U W=2U
RU134 t133 t134 479.566301 rppd L=3.43U W=2U
RU135 t134 t135 479.566301 rppd L=3.43U W=2U
RU136 t135 t136 479.566301 rppd L=3.43U W=2U
RU137 t136 t137 479.566301 rppd L=3.43U W=2U
RU138 t137 t138 479.566301 rppd L=3.43U W=2U
RU139 t138 t139 479.566301 rppd L=3.43U W=2U
RU140 t139 t140 479.566301 rppd L=3.43U W=2U
RU141 t140 t141 479.566301 rppd L=3.43U W=2U
RU142 t141 t142 479.566301 rppd L=3.43U W=2U
RU143 t142 t143 479.566301 rppd L=3.43U W=2U
RU144 t143 t144 479.566301 rppd L=3.43U W=2U
RU145 t144 t145 479.566301 rppd L=3.43U W=2U
RU146 t145 t146 479.566301 rppd L=3.43U W=2U
RU147 t146 t147 479.566301 rppd L=3.43U W=2U
RU148 t147 t148 479.566301 rppd L=3.43U W=2U
RU149 t148 t149 479.566301 rppd L=3.43U W=2U
RU150 t149 t150 479.566301 rppd L=3.43U W=2U
RU151 t150 t151 479.566301 rppd L=3.43U W=2U
RU152 t151 t152 479.566301 rppd L=3.43U W=2U
RU153 t152 t153 479.566301 rppd L=3.43U W=2U
RU154 t153 t154 479.566301 rppd L=3.43U W=2U
RU155 t154 t155 479.566301 rppd L=3.43U W=2U
RU156 t155 t156 479.566301 rppd L=3.43U W=2U
RU157 t156 t157 479.566301 rppd L=3.43U W=2U
RU158 t157 t158 479.566301 rppd L=3.43U W=2U
RU159 t158 t159 479.566301 rppd L=3.43U W=2U
RU160 t159 t160 479.566301 rppd L=3.43U W=2U
RU161 t160 t161 479.566301 rppd L=3.43U W=2U
RU162 t161 t162 479.566301 rppd L=3.43U W=2U
RU163 t162 t163 479.566301 rppd L=3.43U W=2U
RU164 t163 t164 479.566301 rppd L=3.43U W=2U
RU165 t164 t165 479.566301 rppd L=3.43U W=2U
RU166 t165 t166 479.566301 rppd L=3.43U W=2U
RU167 t166 t167 479.566301 rppd L=3.43U W=2U
RU168 t167 t168 479.566301 rppd L=3.43U W=2U
RU169 t168 t169 479.566301 rppd L=3.43U W=2U
RU170 t169 t170 479.566301 rppd L=3.43U W=2U
RU171 t170 t171 479.566301 rppd L=3.43U W=2U
RU172 t171 t172 479.566301 rppd L=3.43U W=2U
RU173 t172 t173 479.566301 rppd L=3.43U W=2U
RU174 t173 t174 479.566301 rppd L=3.43U W=2U
RU175 t174 t175 479.566301 rppd L=3.43U W=2U
RU176 t175 t176 479.566301 rppd L=3.43U W=2U
RU177 t176 t177 479.566301 rppd L=3.43U W=2U
RU178 t177 t178 479.566301 rppd L=3.43U W=2U
RU179 t178 t179 479.566301 rppd L=3.43U W=2U
RU180 t179 t180 479.566301 rppd L=3.43U W=2U
RU181 t180 t181 479.566301 rppd L=3.43U W=2U
RU182 t181 t182 479.566301 rppd L=3.43U W=2U
RU183 t182 t183 479.566301 rppd L=3.43U W=2U
RU184 t183 t184 479.566301 rppd L=3.43U W=2U
RU185 t184 t185 479.566301 rppd L=3.43U W=2U
RU186 t185 t186 479.566301 rppd L=3.43U W=2U
RU187 t186 t187 479.566301 rppd L=3.43U W=2U
RU188 t187 t188 479.566301 rppd L=3.43U W=2U
RU189 t188 t189 479.566301 rppd L=3.43U W=2U
RU190 t189 t190 479.566301 rppd L=3.43U W=2U
RU191 t190 t191 479.566301 rppd L=3.43U W=2U
RU192 t191 t192 479.566301 rppd L=3.43U W=2U
RU193 t192 t193 479.566301 rppd L=3.43U W=2U
RU194 t193 t194 479.566301 rppd L=3.43U W=2U
RU195 t194 t195 479.566301 rppd L=3.43U W=2U
RU196 t195 t196 479.566301 rppd L=3.43U W=2U
RU197 t196 t197 479.566301 rppd L=3.43U W=2U
RU198 t197 t198 479.566301 rppd L=3.43U W=2U
RU199 t198 t199 479.566301 rppd L=3.43U W=2U
RU200 t199 t200 479.566301 rppd L=3.43U W=2U
RU201 t200 t201 479.566301 rppd L=3.43U W=2U
RU202 t201 t202 479.566301 rppd L=3.43U W=2U
RU203 t202 t203 479.566301 rppd L=3.43U W=2U
RU204 t203 t204 479.566301 rppd L=3.43U W=2U
RU205 t204 t205 479.566301 rppd L=3.43U W=2U
RU206 t205 t206 479.566301 rppd L=3.43U W=2U
RU207 t206 t207 479.566301 rppd L=3.43U W=2U
RU208 t207 t208 479.566301 rppd L=3.43U W=2U
RU209 t208 t209 479.566301 rppd L=3.43U W=2U
RU210 t209 t210 479.566301 rppd L=3.43U W=2U
RU211 t210 t211 479.566301 rppd L=3.43U W=2U
RU212 t211 t212 479.566301 rppd L=3.43U W=2U
RU213 t212 t213 479.566301 rppd L=3.43U W=2U
RU214 t213 t214 479.566301 rppd L=3.43U W=2U
RU215 t214 t215 479.566301 rppd L=3.43U W=2U
RU216 t215 t216 479.566301 rppd L=3.43U W=2U
RU217 t216 t217 479.566301 rppd L=3.43U W=2U
RU218 t217 t218 479.566301 rppd L=3.43U W=2U
RU219 t218 t219 479.566301 rppd L=3.43U W=2U
RU220 t219 t220 479.566301 rppd L=3.43U W=2U
RU221 t220 t221 479.566301 rppd L=3.43U W=2U
RU222 t221 t222 479.566301 rppd L=3.43U W=2U
RU223 t222 t223 479.566301 rppd L=3.43U W=2U
RU224 t223 t224 479.566301 rppd L=3.43U W=2U
RU225 t224 t225 479.566301 rppd L=3.43U W=2U
RU226 t225 t226 479.566301 rppd L=3.43U W=2U
RU227 t226 t227 479.566301 rppd L=3.43U W=2U
RU228 t227 t228 479.566301 rppd L=3.43U W=2U
RU229 t228 t229 479.566301 rppd L=3.43U W=2U
RU230 t229 t230 479.566301 rppd L=3.43U W=2U
RU231 t230 t231 479.566301 rppd L=3.43U W=2U
RU232 t231 t232 479.566301 rppd L=3.43U W=2U
RU233 t232 t233 479.566301 rppd L=3.43U W=2U
RU234 t233 t234 479.566301 rppd L=3.43U W=2U
RU235 t234 t235 479.566301 rppd L=3.43U W=2U
RU236 t235 t236 479.566301 rppd L=3.43U W=2U
RU237 t236 t237 479.566301 rppd L=3.43U W=2U
RU238 t237 t238 479.566301 rppd L=3.43U W=2U
RU239 t238 t239 479.566301 rppd L=3.43U W=2U
RU240 t239 t240 479.566301 rppd L=3.43U W=2U
RU241 t240 t241 479.566301 rppd L=3.43U W=2U
RU242 t241 t242 479.566301 rppd L=3.43U W=2U
RU243 t242 t243 479.566301 rppd L=3.43U W=2U
RU244 t243 t244 479.566301 rppd L=3.43U W=2U
RU245 t244 t245 479.566301 rppd L=3.43U W=2U
RU246 t245 t246 479.566301 rppd L=3.43U W=2U
RU247 t246 t247 479.566301 rppd L=3.43U W=2U
RU248 t247 t248 479.566301 rppd L=3.43U W=2U
RU249 t248 t249 479.566301 rppd L=3.43U W=2U
RU250 t249 t250 479.566301 rppd L=3.43U W=2U
RU251 t250 t251 479.566301 rppd L=3.43U W=2U
RU252 t251 t252 479.566301 rppd L=3.43U W=2U
RU253 t252 t253 479.566301 rppd L=3.43U W=2U
RU254 t253 t254 479.566301 rppd L=3.43U W=2U
RU255 t254 cb3 479.566301 rppd L=3.43U W=2U
Qx1_Q3 cb3 cb3 vss vss npn13g2
Mx2_MTAIL tail FB,OUT vdd vdd pfet L=1U W=10U
Mx2_MP1 d1 IN_P,SNS2 tail vdd pfet L=1U W=20U
Mx2_MP2 d2 IN_N,SNS1 tail vdd pfet L=1U W=20U
Mx2_MP3 pn pn vdd vdd pfet L=1U W=10U
Mx2_MP4 FB,OUT pn vdd vdd pfet L=1U W=10U
Mx2_MN1 d1 d1 vss vss nfet L=1U W=10U
Mx2_MN2 d2 d2 vss vss nfet L=1U W=10U
Mx2_MN3 FB,OUT d1 vss vss nfet L=1U W=10U
Mx2_MN4 pn d2 vss vss nfet L=1U W=10U
Rx3_RPU vdd det 1999501.666667 rhigh L=1411.3U W=1U
Mx3_MSENSE det IN_N,SNS1 vss vss nfet L=0.5U W=10U
Mx3_MKFB FB,OUT det vss vss nfet L=0.5U W=2U
.end
