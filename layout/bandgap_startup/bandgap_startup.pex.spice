* extracted by klt extract --deck sg13g2
* parasitic model (--parasitics):
* - capacitance: net-to-ground for every net's own (non-coupled) area/perimeter, plus net-to-net for the vertical-overlap coupling `coupling` describes below -- a coupled net pair gets a direct capacitor between their two hub nodes, not just capacitors to the deck's ground/substrate net
* - coupling: vertical overlap (crossover) unconditionally -- where one net's conductor on an adjacent metal level sits directly over another *distinct* net's conductor, that overlap area is charged between the two nets instead of to ground (issue #760) -- plus lateral (same-layer, sidewall) coupling, but only for a net pair naming one of the caller's declared `--critical-net` nets (issue #976): facing-edge length within that layer's own minimum-spacing lookback is charged between the two nets, *additively* (not deducted from either net's substrate fringe term, unlike the vertical case -- a known simplification). Any same-layer pair with neither side named `--critical-net`, and fringe shielding in general, are still not modelled
* - resistance: single lumped series resistance per net, distributed as a star across that net's device terminals (issue #592) -- not a per-segment, distributed RC ladder, *unless* `--distributed-rc` names this net via `--critical-net` (issue #977, Epic #709 Phase 2b): then the net's terminals are ordered along their approximate physical spread and its total R/C is broken into a chain of per-segment resistors (segment length proportional to inter-terminal distance) with a ground capacitor at each terminal node (proportional to its adjacent segment length/2), instead of one star hub -- still an approximation (terminal position is a device-placement proxy, not true per-segment routing geometry), but a strictly finer-grained one than the single-hub star
* - frequency: quasi-static -- one frequency-independent R and C per net; no skin effect, no distributed transmission-line behavior
* - substrate tie: 1e+12 ohm to ground -- the substrate is capacitively floating in transient analysis (DC reference only); see --substrate-tie-ohms
.GLOBAL vsubs

* cell bandgap_startup
* pin DET
* pin FB
* pin SNS1
* pin VDD
* pin VSS
.SUBCKT bandgap_startup DET FB SNS1 VDD VSS
* device instance $1 r0 *1 0,0 nfet
M$1 DET__t0 SNS1 VSS__t0 VSS__t3 nfet L=0.5U W=10U AS=4P AD=4P PS=20.8U PD=20.8U
* device instance $2 r0 *1 20,0 nfet
M$2 FB__t0 DET__t1 VSS__t1 VSS__t4 nfet L=0.5U W=2U AS=0.8P AD=0.8P PS=4.8U
+ PD=4.8U
* device instance $3 r0 *1 24.37,26.79 rhigh
X$3 VDD__t0 DET__t2 VSS__t2 rhigh r=1999501.66667 L=1411.3U W=1U
* device instance DET_t0 r0 *1 0,0
RDET_t0 DET__t0 DET 7.93106173611
* device instance DET_t1 r0 *1 0,0
RDET_t1 DET__t1 DET 4.74606489254
* device instance DET_t2 r0 *1 0,0
RDET_t2 DET__t2 DET 9.30377337135
* device instance DET r0 *1 0,0
CDET DET vsubs 5.609171e-15
* device instance FB_t0 r0 *1 0,0
RFB_t0 FB__t0 FB 0.6286
* device instance FB r0 *1 0,0
CFB FB vsubs 2.1056e-16
* device instance VDD_t0 r0 *1 0,0
RVDD_t0 VDD__t0 VDD 0.308
* device instance VDD r0 *1 0,0
CVDD VDD vsubs 1.74934e-16
* device instance VSS_t0 r0 *1 0,0
RVSS_t0 VSS__t0 VSS 2.29129752909
* device instance VSS_t1 r0 *1 0,0
RVSS_t1 VSS__t1 VSS 1.46497629042
* device instance VSS_t2 r0 *1 0,0
RVSS_t2 VSS__t2 VSS 3.99625236097
* device instance VSS_t3 r0 *1 0,0
RVSS_t3 VSS__t3 VSS 2.29129752909
* device instance VSS_t4 r0 *1 0,0
RVSS_t4 VSS__t4 VSS 1.46497629042
* device instance VSS r0 *1 0,0
CVSS VSS vsubs 2.470295e-15
* device instance vsubs_dctie r0 *1 0,0
Rvsubs_dctie vsubs 0 1e+12
.ENDS bandgap_startup
