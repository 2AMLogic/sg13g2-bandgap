* extracted by klt extract --deck sg13g2
* parasitic model (--parasitics):
* - capacitance: net-to-ground for every net's own (non-coupled) area/perimeter, plus net-to-net for the vertical-overlap coupling `coupling` describes below -- a coupled net pair gets a direct capacitor between their two hub nodes, not just capacitors to the deck's ground/substrate net
* - coupling: vertical overlap (crossover) unconditionally -- where one net's conductor on an adjacent metal level sits directly over another *distinct* net's conductor, that overlap area is charged between the two nets instead of to ground (issue #760) -- plus lateral (same-layer, sidewall) coupling, but only for a net pair naming one of the caller's declared `--critical-net` nets (issue #976): facing-edge length within that layer's own minimum-spacing lookback is charged between the two nets, *additively* (not deducted from either net's substrate fringe term, unlike the vertical case -- a known simplification). Any same-layer pair with neither side named `--critical-net`, and fringe shielding in general, are still not modelled
* - resistance: single lumped series resistance per net, distributed as a star across that net's device terminals (issue #592) -- not a per-segment, distributed RC ladder, *unless* `--distributed-rc` names this net via `--critical-net` (issue #977, Epic #709 Phase 2b): then the net's terminals are ordered along their approximate physical spread and its total R/C is broken into a chain of per-segment resistors (segment length proportional to inter-terminal distance) with a ground capacitor at each terminal node (proportional to its adjacent segment length/2), instead of one star hub -- still an approximation (terminal position is a device-placement proxy, not true per-segment routing geometry), but a strictly finer-grained one than the single-hub star
* - frequency: quasi-static -- one frequency-independent R and C per net; no skin effect, no distributed transmission-line behavior

* cell bandgap_startup
* pin det
* pin fb
* pin vss
* pin vsubs
.SUBCKT bandgap_startup det fb vss vsubs
* device instance $1 r0 *1 0,0 nfet
M$1 det__t1 \$4 vss__t0 vsubs nfet L=0.5U W=10U AS=4P AD=4P PS=20.8U PD=20.8U
* device instance $2 r0 *1 20,0 nfet
M$2 fb__t0 det__t2 vss__t1 vsubs nfet L=0.5U W=2U AS=0.8P AD=0.8P PS=4.8U
+ PD=4.8U
* device instance $3 r0 *1 705.65,20 rhigh
R$3 \$5__t0 det__t0 vsubs 1919368 rhigh
* device instance _5_t0 r0 *1 0,0
R_5_t0 \$5__t0 \$5 0.264
* device instance _5 r0 *1 0,0
C_5 \$5 vsubs 1.55598e-16
* device instance det_t0 r0 *1 0,0
Rdet_t0 det__t0 det 266.808047442
* device instance det_t1 r0 *1 0,0
Rdet_t1 det__t1 det 139.15243699
* device instance det_t2 r0 *1 0,0
Rdet_t2 det__t2 det 127.655815568
* device instance det r0 *1 0,0
Cdet det vsubs 1.30736768e-13
* device instance fb_t0 r0 *1 0,0
Rfb_t0 fb__t0 fb 0.6286
* device instance fb r0 *1 0,0
Cfb fb vsubs 2.1056e-16
* device instance vss_t0 r0 *1 0,0
Rvss_t0 vss__t0 vss 5.4071
* device instance vss_t1 r0 *1 0,0
Rvss_t1 vss__t1 vss 5.4071
* device instance vss r0 *1 0,0
Cvss vss vsubs 2.34311e-15
* device instance vsubs_dctie r0 *1 0,0
Rvsubs_dctie vsubs 0 1e+12
.ENDS bandgap_startup
