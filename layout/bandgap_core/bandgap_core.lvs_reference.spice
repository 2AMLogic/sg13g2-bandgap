* Auto-generated by layout/lvs_reference.py -- DO NOT EDIT BY HAND.
* Source: design/netlist/bandgap_core.spice
* Plain-element form for `klt lvs` (see this file's own module
* docstring for why the subckt-call form above cannot be used
* directly, and why klt's own `reference.form: "subckt-call"`
* converter cannot handle this circuit's mixed MOS/BJT/resistor
* device set either).
M1 sns1 fb vdd vdd pfet L=1U W=10U
Q1 sns1 sns1 vss vss npn13g2
M2 sns2 fb vdd vdd pfet L=1U W=10U
R2 sns2 cb2 10751.0
Q2 cb2 cb2 vss vss npn13g2
M3 vref fb vdd vdd pfet L=1U W=10U
R1 vref cb3 90285.0
Q3 cb3 cb3 vss vss npn13g2
.end
