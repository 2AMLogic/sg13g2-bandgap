* extracted by klt extract --deck sg13g2
* parasitic model (--parasitics):
* - capacitance: net-to-ground for every net's own (non-coupled) area/perimeter, plus net-to-net for the vertical-overlap coupling `coupling` describes below -- a coupled net pair gets a direct capacitor between their two hub nodes, not just capacitors to the deck's ground/substrate net
* - coupling: vertical overlap (crossover) unconditionally -- where one net's conductor on an adjacent metal level sits directly over another *distinct* net's conductor, that overlap area is charged between the two nets instead of to ground (issue #760) -- plus lateral (same-layer, sidewall) coupling, but only for a net pair naming one of the caller's declared `--critical-net` nets (issue #976): facing-edge length within that layer's own minimum-spacing lookback is charged between the two nets, *additively* (not deducted from either net's substrate fringe term, unlike the vertical case -- a known simplification). Any same-layer pair with neither side named `--critical-net`, and fringe shielding in general, are still not modelled
* - resistance: single lumped series resistance per net, distributed as a star across that net's device terminals (issue #592) -- not a per-segment, distributed RC ladder, *unless* `--distributed-rc` names this net via `--critical-net` (issue #977, Epic #709 Phase 2b): then the net's terminals are ordered along their approximate physical spread and its total R/C is broken into a chain of per-segment resistors (segment length proportional to inter-terminal distance) with a ground capacitor at each terminal node (proportional to its adjacent segment length/2), instead of one star hub -- still an approximation (terminal position is a device-placement proxy, not true per-segment routing geometry), but a strictly finer-grained one than the single-hub star
* - frequency: quasi-static -- one frequency-independent R and C per net; no skin effect, no distributed transmission-line behavior

* cell bandgap_core
* pin sns1
* pin sns2
* pin vdd
* pin vref
* pin cb2
* pin cb3
* pin vss
.SUBCKT bandgap_core sns1 sns2 vdd vref cb2 cb3 vss
* device instance $1 r0 *1 0,22 pfet
M$1 vdd \$9 sns1 \$11 pfet L=1U W=10U AS=4P AD=4P PS=20.8U PD=20.8U
* device instance $2 r0 *1 45,22 pfet
M$2 vdd \$9 sns2 \$12 pfet L=1U W=10U AS=4P AD=4P PS=20.8U PD=20.8U
* device instance $3 r0 *1 110,22 pfet
M$3 vdd \$9 vref \$13 pfet L=1U W=10U AS=4P AD=4P PS=20.8U PD=20.8U
.ENDS bandgap_core
