* extracted by klt extract --deck sg13g2
* parasitic model (--parasitics):
* - capacitance: net-to-ground for every net's own (non-coupled) area/perimeter, plus net-to-net for the vertical-overlap coupling `coupling` describes below -- a coupled net pair gets a direct capacitor between their two hub nodes, not just capacitors to the deck's ground/substrate net
* - coupling: vertical overlap (crossover) unconditionally -- where one net's conductor on an adjacent metal level sits directly over another *distinct* net's conductor, that overlap area is charged between the two nets instead of to ground (issue #760) -- plus lateral (same-layer, sidewall) coupling, but only for a net pair naming one of the caller's declared `--critical-net` nets (issue #976): facing-edge length within that layer's own minimum-spacing lookback is charged between the two nets, *additively* (not deducted from either net's substrate fringe term, unlike the vertical case -- a known simplification). Any same-layer pair with neither side named `--critical-net`, and fringe shielding in general, are still not modelled
* - resistance: single lumped series resistance per net, distributed as a star across that net's device terminals (issue #592) -- not a per-segment, distributed RC ladder, *unless* `--distributed-rc` names this net via `--critical-net` (issue #977, Epic #709 Phase 2b): then the net's terminals are ordered along their approximate physical spread and its total R/C is broken into a chain of per-segment resistors (segment length proportional to inter-terminal distance) with a ground capacitor at each terminal node (proportional to its adjacent segment length/2), instead of one star hub -- still an approximation (terminal position is a device-placement proxy, not true per-segment routing geometry), but a strictly finer-grained one than the single-hub star
* - frequency: quasi-static -- one frequency-independent R and C per net; no skin effect, no distributed transmission-line behavior

* cell bandgap_core
* pin CB2
* pin CB3
* pin FB
* pin SNS1
* pin SNS2
* pin VDD
* pin VREF
* pin vsubs
* pin VSS
.SUBCKT bandgap_core CB2 CB3 FB SNS1 SNS2 VDD VREF vsubs VSS
* device instance $1 r0 *1 0,22 pfet
M$1 VDD__t0 FB SNS1__t0 VDD__t1 pfet L=1U W=10U AS=4P AD=4P PS=20.8U PD=20.8U
* device instance $2 r0 *1 45,22 pfet
M$2 VDD__t2 FB SNS2__t1 VDD__t3 pfet L=1U W=9U AS=3.6P AD=3.6P PS=18.8U PD=18.8U
* device instance $3 r0 *1 57,22 pfet
M$3 VDD__t4 FB SNS2__t2 VDD__t5 pfet L=1U W=1U AS=0.4P AD=0.4P PS=2.8U PD=2.8U
* device instance $4 r0 *1 110,22 pfet
M$4 VDD__t6 FB VREF__t1 VDD__t7 pfet L=1U W=8U AS=3.2P AD=3.2P PS=16.8U PD=16.8U
* device instance $5 r0 *1 122,22 pfet
M$5 VDD__t11 FB VREF__t3 VDD__t9 pfet L=1U W=1U AS=0.4P AD=0.4P PS=2.8U PD=2.8U
* device instance $6 r0 *1 134,22 pfet
M$6 VDD__t10 FB VREF__t2 VDD__t8 pfet L=1U W=1U AS=0.4P AD=0.4P PS=2.8U PD=2.8U
* device instance $7 r0 *1 41.35,40 rppd
R$7 SNS2__t0 CB2__t0 vsubs 10751 rppd
* device instance $8 r0 *1 255.5,60 rppd
R$8 VREF__t0 CB3__t0 vsubs 66430 rppd
* device instance CB2_t0 r0 *1 0,0
RCB2_t0 CB2__t0 CB2 27.5568
* device instance CB2 r0 *1 0,0
CCB2 CB2 vsubs 8.704932e-15
* device instance CB3_t0 r0 *1 0,0
RCB3_t0 CB3__t0 CB3 117.7002
* device instance CB3 r0 *1 0,0
CCB3 CB3 vsubs 3.5673741e-14
* device instance SNS1_t0 r0 *1 0,0
RSNS1_t0 SNS1__t0 SNS1 15.1283
* device instance SNS1 r0 *1 0,0
CSNS1 SNS1 vsubs 4.244144e-15
* device instance SNS2_t0 r0 *1 0,0
RSNS2_t0 SNS2__t0 SNS2 10.1243713303
* device instance SNS2_t1 r0 *1 0,0
RSNS2_t1 SNS2__t1 SNS2 4.91814556153
* device instance SNS2_t2 r0 *1 0,0
RSNS2_t2 SNS2__t2 SNS2 8.17758310814
* device instance SNS2 r0 *1 0,0
CSNS2 SNS2 vsubs 7.036193e-15
* device instance VDD_t0 r0 *1 0,0
RVDD_t0 VDD__t0 VDD 6.75282045455
* device instance VDD_t1 r0 *1 0,0
RVDD_t1 VDD__t1 VDD 6.75282045455
* device instance VDD_t2 r0 *1 0,0
RVDD_t2 VDD__t2 VDD 2.8569625
* device instance VDD_t3 r0 *1 0,0
RVDD_t3 VDD__t3 VDD 2.8569625
* device instance VDD_t4 r0 *1 0,0
RVDD_t4 VDD__t4 VDD 1.81806704545
* device instance VDD_t5 r0 *1 0,0
RVDD_t5 VDD__t5 VDD 1.81806704545
* device instance VDD_t6 r0 *1 0,0
RVDD_t6 VDD__t6 VDD 2.77038787879
* device instance VDD_t7 r0 *1 0,0
RVDD_t7 VDD__t7 VDD 2.77038787879
* device instance VDD_t8 r0 *1 0,0
RVDD_t8 VDD__t8 VDD 4.84817878788
* device instance VDD_t9 r0 *1 0,0
RVDD_t9 VDD__t9 VDD 3.80928333333
* device instance VDD_t10 r0 *1 0,0
RVDD_t10 VDD__t10 VDD 4.84817878788
* device instance VDD_t11 r0 *1 0,0
RVDD_t11 VDD__t11 VDD 3.80928333333
* device instance VDD r0 *1 0,0
CVDD VDD vsubs 1.314593e-14
* device instance VREF_t0 r0 *1 0,0
RVREF_t0 VREF__t0 VREF 24.8473212291
* device instance VREF_t1 r0 *1 0,0
RVREF_t1 VREF__t1 VREF 11.065018194
* device instance VREF_t2 r0 *1 0,0
RVREF_t2 VREF__t2 VREF 5.58302016718
* device instance VREF_t3 r0 *1 0,0
RVREF_t3 VREF__t3 VREF 8.2824404097
* device instance VREF r0 *1 0,0
CVREF VREF vsubs 1.5014553e-14
* device instance VSS r0 *1 0,0
RVSS VSS VSS__par 7.5152
* device instance VSS r0 *1 0,0
CVSS VSS__par vsubs 1.2491113e-14
* device instance cc_CB2_VDD r0 *1 0,0
Ccc_CB2_VDD CB2 VDD 8.235e-18
* device instance cc_CB2_VSS r0 *1 0,0
Ccc_CB2_VSS CB2 VSS__par 3.0251e-17
* device instance cc_CB3_VDD r0 *1 0,0
Ccc_CB3_VDD CB3 VDD 8.235e-18
* device instance cc_CB3_VREF r0 *1 0,0
Ccc_CB3_VREF CB3 VREF 8.235e-18
* device instance cc_CB3_VSS r0 *1 0,0
Ccc_CB3_VSS CB3 VSS__par 2.0167e-17
* device instance cc_SNS1_VSS r0 *1 0,0
Ccc_SNS1_VSS SNS1 VSS__par 3.0251e-17
* device instance cc_SNS2_VDD r0 *1 0,0
Ccc_SNS2_VDD SNS2 VDD 8.235e-18
* device instance cc_VDD_VREF r0 *1 0,0
Ccc_VDD_VREF VDD VREF 8.235e-18
* device instance vsubs_dctie r0 *1 0,0
Rvsubs_dctie vsubs 0 1e+12
.ENDS bandgap_core
