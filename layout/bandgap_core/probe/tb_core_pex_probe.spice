* sg13g2-bandgap -- bandgap_core PEX one-point sanity probe (issue #272).
* GENERATED by layout/bandgap_core/probe/make_probe_netlist.py from
* layout/bandgap_core/bandgap_core.pex.spice -- do not edit by hand;
* edit the generator and re-run it (`--check` verifies this file is
* current against the committed extraction).
*
* NOT an evidence record. One operating point at
* corner=typ temp=27C vdd=3.30V, whose job is to make
* layout/README.md's "One-point probe" table re-runnable. The five
* *-pex experiments' own PVT grids against this extraction are #275.
*
* Extracted devices re-encoded: 6 pfet, 257 rppd.
* Wire-parasitic cards copied verbatim: 833.
* Bipolars (XQ1-XQ3) spliced from design/netlist/bandgap_core.spice --
* the curated sg13g2 deck does not recognise npn13G2, so they are not
* in the extraction; see layout/README.md 'Permanent blockers'.
* Merged tap net T001|T003|T007|T015|T031|T063|T127|TN0 renamed to
* tn0_merged ('|' is not a legal ngspice node name).

.lib "@PDK@/libs.tech/ngspice/models/cornerHBT.lib" hbt_typ
.lib "@PDK@/libs.tech/ngspice/models/cornerMOShv.lib" mos_tt
.lib "@PDK@/libs.tech/ngspice/models/cornerRES.lib" res_typ

.options temp=27 tnom=27

Vvdd vdd 0 dc 3.30
Vvss vss 0 dc 0

* FIXTURE 1 -- open-loop mirror bias (no error amplifier in this cell):
* a diode-connected replica carrying a 5 uA reference sets the shared
* gate net, exactly as sim/core-open-loop-bias-pex does.
XM0 fb fb vdd vdd sg13_hv_pmos w=10u l=1u ng=1 m=1
Ibias fb vss dc 5u

* FIXTURE 2 -- per-leg ammeter; FIXTURE 3 -- body tied to the ideal vdd
* rather than through its own body hub leg (that leg carries no current
* this probe measures). Drain/source hub nodes are each leg's own, read
* off its extracted card.
XM1 vdd__t0 fb m1s vdd sg13_hv_pmos w=10U l=1U as=4P ad=4P ps=20.8U pd=20.8U ng=1 m=1
Vm1 m1s sns1__t0 dc 0
XM2 vdd__t2 fb m2s vdd sg13_hv_pmos w=9U l=1U as=3.6P ad=3.6P ps=18.8U pd=18.8U ng=1 m=1
Vm2 m2s sns2__t0 dc 0
XM3 vdd__t4 fb m3s vdd sg13_hv_pmos w=1U l=1U as=0.4P ad=0.4P ps=2.8U pd=2.8U ng=1 m=1
Vm3 m3s sns2__t1 dc 0
XM4 vdd__t6 fb m4s vdd sg13_hv_pmos w=8U l=1U as=3.2P ad=3.2P ps=16.8U pd=16.8U ng=1 m=1
Vm4 m4s vref__t0 dc 0
XM5 vdd__t10 fb m5s vdd sg13_hv_pmos w=1U l=1U as=0.4P ad=0.4P ps=2.8U pd=2.8U ng=1 m=1
Vm5 m5s vref__t2 dc 0
XM6 vdd__t11 fb m6s vdd sg13_hv_pmos w=1U l=1U as=0.4P ad=0.4P ps=2.8U pd=2.8U ng=1 m=1
Vm6 m6s vref__t3 dc 0

* Extracted rppd devices -- the 255 ladder units plus R1 (l=37.2u) and
* R2 (l=82.7u), each at its own extracted geometry. The extraction's
* `r=` field is klt's sheet estimate, not a subckt parameter, and is a
* lower bound on a short segment (klayout-tools#2652) -- dropped here;
* the real r3_cmc compact model computes the value from w/l.
XR7 tn0_merged__t0 tn0_merged__t1 vsubs rppd w=2U l=3.43U m=1 b=0
XR8 t030__t1 t029__t0 vsubs rppd w=2U l=3.43U m=1 b=0
XR9 t030__t0 tn0_merged__t6 vsubs rppd w=2U l=3.43U m=1 b=0
XR10 t060__t1 t059__t0 vsubs rppd w=2U l=3.43U m=1 b=0
XR11 t060__t0 t061__t0 vsubs rppd w=2U l=3.43U m=1 b=0
XR12 t090__t1 t089__t0 vsubs rppd w=2U l=3.43U m=1 b=0
XR13 t090__t0 t091__t0 vsubs rppd w=2U l=3.43U m=1 b=0
XR14 t120__t1 t119__t0 vsubs rppd w=2U l=3.43U m=1 b=0
XR15 t120__t0 t121__t0 vsubs rppd w=2U l=3.43U m=1 b=0
XR16 t150__t1 t149__t0 vsubs rppd w=2U l=3.43U m=1 b=0
XR17 t150__t0 t151__t0 vsubs rppd w=2U l=3.43U m=1 b=0
XR18 t180__t1 t179__t0 vsubs rppd w=2U l=3.43U m=1 b=0
XR19 t180__t0 t181__t0 vsubs rppd w=2U l=3.43U m=1 b=0
XR20 t210__t1 t209__t0 vsubs rppd w=2U l=3.43U m=1 b=0
XR21 t210__t0 t211__t0 vsubs rppd w=2U l=3.43U m=1 b=0
XR22 t240__t1 t239__t0 vsubs rppd w=2U l=3.43U m=1 b=0
XR23 t240__t0 t241__t0 vsubs rppd w=2U l=3.43U m=1 b=0
XR24 tn0_merged__t13 t002__t0 vsubs rppd w=2U l=3.43U m=1 b=0
XR25 t029__t1 t028__t0 vsubs rppd w=2U l=3.43U m=1 b=0
XR26 tn0_merged__t12 t032__t0 vsubs rppd w=2U l=3.43U m=1 b=0
XR27 t059__t1 t058__t0 vsubs rppd w=2U l=3.43U m=1 b=0
XR28 t061__t1 t062__t0 vsubs rppd w=2U l=3.43U m=1 b=0
XR29 t089__t1 t088__t0 vsubs rppd w=2U l=3.43U m=1 b=0
XR30 t091__t1 t092__t0 vsubs rppd w=2U l=3.43U m=1 b=0
XR31 t119__t1 t118__t0 vsubs rppd w=2U l=3.43U m=1 b=0
XR32 t121__t1 t122__t0 vsubs rppd w=2U l=3.43U m=1 b=0
XR33 t149__t1 t148__t0 vsubs rppd w=2U l=3.43U m=1 b=0
XR34 t151__t1 t152__t0 vsubs rppd w=2U l=3.43U m=1 b=0
XR35 t179__t1 t178__t0 vsubs rppd w=2U l=3.43U m=1 b=0
XR36 t181__t1 t182__t0 vsubs rppd w=2U l=3.43U m=1 b=0
XR37 t209__t1 t208__t0 vsubs rppd w=2U l=3.43U m=1 b=0
XR38 t211__t1 t212__t0 vsubs rppd w=2U l=3.43U m=1 b=0
XR39 t239__t1 t238__t0 vsubs rppd w=2U l=3.43U m=1 b=0
XR40 t241__t1 t242__t0 vsubs rppd w=2U l=3.43U m=1 b=0
XR41 t002__t1 tn0_merged__t8 vsubs rppd w=2U l=3.43U m=1 b=0
XR42 t028__t1 t027__t0 vsubs rppd w=2U l=3.43U m=1 b=0
XR43 t032__t1 t033__t0 vsubs rppd w=2U l=3.43U m=1 b=0
XR44 t058__t1 t057__t0 vsubs rppd w=2U l=3.43U m=1 b=0
XR45 t062__t1 tn0_merged__t7 vsubs rppd w=2U l=3.43U m=1 b=0
XR46 t088__t1 t087__t0 vsubs rppd w=2U l=3.43U m=1 b=0
XR47 t092__t1 t093__t0 vsubs rppd w=2U l=3.43U m=1 b=0
XR48 t118__t1 t117__t0 vsubs rppd w=2U l=3.43U m=1 b=0
XR49 t122__t1 t123__t0 vsubs rppd w=2U l=3.43U m=1 b=0
XR50 t148__t1 t147__t0 vsubs rppd w=2U l=3.43U m=1 b=0
XR51 t152__t1 t153__t0 vsubs rppd w=2U l=3.43U m=1 b=0
XR52 t178__t1 t177__t0 vsubs rppd w=2U l=3.43U m=1 b=0
XR53 t182__t1 t183__t0 vsubs rppd w=2U l=3.43U m=1 b=0
XR54 t208__t1 t207__t0 vsubs rppd w=2U l=3.43U m=1 b=0
XR55 t212__t1 t213__t0 vsubs rppd w=2U l=3.43U m=1 b=0
XR56 t238__t1 t237__t0 vsubs rppd w=2U l=3.43U m=1 b=0
XR57 t242__t1 t243__t0 vsubs rppd w=2U l=3.43U m=1 b=0
XR58 tn0_merged__t15 t004__t0 vsubs rppd w=2U l=3.43U m=1 b=0
XR59 t027__t1 t026__t0 vsubs rppd w=2U l=3.43U m=1 b=0
XR60 t033__t1 t034__t0 vsubs rppd w=2U l=3.43U m=1 b=0
XR61 t057__t1 t056__t0 vsubs rppd w=2U l=3.43U m=1 b=0
XR62 tn0_merged__t14 t064__t0 vsubs rppd w=2U l=3.43U m=1 b=0
XR63 t087__t1 t086__t0 vsubs rppd w=2U l=3.43U m=1 b=0
XR64 t093__t1 t094__t0 vsubs rppd w=2U l=3.43U m=1 b=0
XR65 t117__t1 t116__t0 vsubs rppd w=2U l=3.43U m=1 b=0
XR66 t123__t1 t124__t0 vsubs rppd w=2U l=3.43U m=1 b=0
XR67 t147__t1 t146__t0 vsubs rppd w=2U l=3.43U m=1 b=0
XR68 t153__t1 t154__t0 vsubs rppd w=2U l=3.43U m=1 b=0
XR69 t177__t1 t176__t0 vsubs rppd w=2U l=3.43U m=1 b=0
XR70 t183__t1 t184__t0 vsubs rppd w=2U l=3.43U m=1 b=0
XR71 t207__t1 t206__t0 vsubs rppd w=2U l=3.43U m=1 b=0
XR72 t213__t1 t214__t0 vsubs rppd w=2U l=3.43U m=1 b=0
XR73 t237__t1 t236__t0 vsubs rppd w=2U l=3.43U m=1 b=0
XR74 t243__t1 t244__t0 vsubs rppd w=2U l=3.43U m=1 b=0
XR75 t004__t1 t005__t0 vsubs rppd w=2U l=3.43U m=1 b=0
XR76 t026__t1 t025__t0 vsubs rppd w=2U l=3.43U m=1 b=0
XR77 t034__t1 t035__t0 vsubs rppd w=2U l=3.43U m=1 b=0
XR78 t056__t1 t055__t0 vsubs rppd w=2U l=3.43U m=1 b=0
XR79 t064__t1 t065__t0 vsubs rppd w=2U l=3.43U m=1 b=0
XR80 t086__t1 t085__t0 vsubs rppd w=2U l=3.43U m=1 b=0
XR81 t094__t1 t095__t0 vsubs rppd w=2U l=3.43U m=1 b=0
XR82 t116__t1 t115__t0 vsubs rppd w=2U l=3.43U m=1 b=0
XR83 t124__t1 t125__t0 vsubs rppd w=2U l=3.43U m=1 b=0
XR84 t146__t1 t145__t0 vsubs rppd w=2U l=3.43U m=1 b=0
XR85 t154__t1 t155__t0 vsubs rppd w=2U l=3.43U m=1 b=0
XR86 t176__t1 t175__t0 vsubs rppd w=2U l=3.43U m=1 b=0
XR87 t184__t1 t185__t0 vsubs rppd w=2U l=3.43U m=1 b=0
XR88 t206__t1 t205__t0 vsubs rppd w=2U l=3.43U m=1 b=0
XR89 t214__t1 t215__t0 vsubs rppd w=2U l=3.43U m=1 b=0
XR90 t236__t1 t235__t0 vsubs rppd w=2U l=3.43U m=1 b=0
XR91 t244__t1 t245__t0 vsubs rppd w=2U l=3.43U m=1 b=0
XR92 t005__t1 t006__t0 vsubs rppd w=2U l=3.43U m=1 b=0
XR93 t025__t1 t024__t0 vsubs rppd w=2U l=3.43U m=1 b=0
XR94 t035__t1 t036__t0 vsubs rppd w=2U l=3.43U m=1 b=0
XR95 t055__t1 t054__t0 vsubs rppd w=2U l=3.43U m=1 b=0
XR96 t065__t1 t066__t0 vsubs rppd w=2U l=3.43U m=1 b=0
XR97 t085__t1 t084__t0 vsubs rppd w=2U l=3.43U m=1 b=0
XR98 t095__t1 t096__t0 vsubs rppd w=2U l=3.43U m=1 b=0
XR99 t115__t1 t114__t0 vsubs rppd w=2U l=3.43U m=1 b=0
XR100 t125__t1 t126__t0 vsubs rppd w=2U l=3.43U m=1 b=0
XR101 t145__t1 t144__t0 vsubs rppd w=2U l=3.43U m=1 b=0
XR102 t155__t1 t156__t0 vsubs rppd w=2U l=3.43U m=1 b=0
XR103 t175__t1 t174__t0 vsubs rppd w=2U l=3.43U m=1 b=0
XR104 t185__t1 t186__t0 vsubs rppd w=2U l=3.43U m=1 b=0
XR105 t205__t1 t204__t0 vsubs rppd w=2U l=3.43U m=1 b=0
XR106 t215__t1 t216__t0 vsubs rppd w=2U l=3.43U m=1 b=0
XR107 t235__t1 t234__t0 vsubs rppd w=2U l=3.43U m=1 b=0
XR108 t245__t1 t246__t0 vsubs rppd w=2U l=3.43U m=1 b=0
XR109 t006__t1 tn0_merged__t9 vsubs rppd w=2U l=3.43U m=1 b=0
XR110 t024__t1 t023__t0 vsubs rppd w=2U l=3.43U m=1 b=0
XR111 t036__t1 t037__t0 vsubs rppd w=2U l=3.43U m=1 b=0
XR112 t054__t1 t053__t0 vsubs rppd w=2U l=3.43U m=1 b=0
XR113 t066__t1 t067__t0 vsubs rppd w=2U l=3.43U m=1 b=0
XR114 t084__t1 t083__t0 vsubs rppd w=2U l=3.43U m=1 b=0
XR115 t096__t1 t097__t0 vsubs rppd w=2U l=3.43U m=1 b=0
XR116 t114__t1 t113__t0 vsubs rppd w=2U l=3.43U m=1 b=0
XR117 t126__t1 tn0_merged__t5 vsubs rppd w=2U l=3.43U m=1 b=0
XR118 t144__t1 t143__t0 vsubs rppd w=2U l=3.43U m=1 b=0
XR119 t156__t1 t157__t0 vsubs rppd w=2U l=3.43U m=1 b=0
XR120 t174__t1 t173__t0 vsubs rppd w=2U l=3.43U m=1 b=0
XR121 t186__t1 t187__t0 vsubs rppd w=2U l=3.43U m=1 b=0
XR122 t204__t1 t203__t0 vsubs rppd w=2U l=3.43U m=1 b=0
XR123 t216__t1 t217__t0 vsubs rppd w=2U l=3.43U m=1 b=0
XR124 t234__t1 t233__t0 vsubs rppd w=2U l=3.43U m=1 b=0
XR125 t246__t1 t247__t0 vsubs rppd w=2U l=3.43U m=1 b=0
XR126 tn0_merged__t11 t008__t0 vsubs rppd w=2U l=3.43U m=1 b=0
XR127 t023__t1 t022__t0 vsubs rppd w=2U l=3.43U m=1 b=0
XR128 t037__t1 t038__t0 vsubs rppd w=2U l=3.43U m=1 b=0
XR129 t053__t1 t052__t0 vsubs rppd w=2U l=3.43U m=1 b=0
XR130 t067__t1 t068__t0 vsubs rppd w=2U l=3.43U m=1 b=0
XR131 t083__t1 t082__t0 vsubs rppd w=2U l=3.43U m=1 b=0
XR132 t097__t1 t098__t0 vsubs rppd w=2U l=3.43U m=1 b=0
XR133 t113__t1 t112__t0 vsubs rppd w=2U l=3.43U m=1 b=0
XR134 tn0_merged__t10 t128__t0 vsubs rppd w=2U l=3.43U m=1 b=0
XR135 t143__t1 t142__t0 vsubs rppd w=2U l=3.43U m=1 b=0
XR136 t157__t1 t158__t0 vsubs rppd w=2U l=3.43U m=1 b=0
XR137 t173__t1 t172__t0 vsubs rppd w=2U l=3.43U m=1 b=0
XR138 t187__t1 t188__t0 vsubs rppd w=2U l=3.43U m=1 b=0
XR139 t203__t1 t202__t0 vsubs rppd w=2U l=3.43U m=1 b=0
XR140 t217__t1 t218__t0 vsubs rppd w=2U l=3.43U m=1 b=0
XR141 t233__t1 t232__t0 vsubs rppd w=2U l=3.43U m=1 b=0
XR142 t247__t1 t248__t0 vsubs rppd w=2U l=3.43U m=1 b=0
XR143 sns2__t2 cb2__t0 vsubs rppd w=2U l=82.7U m=1 b=0
XR144 vref__t1 tn0_merged__t2 vsubs rppd w=2U l=37.2U m=1 b=0
XR145 t008__t1 t009__t0 vsubs rppd w=2U l=3.43U m=1 b=0
XR146 t022__t1 t021__t0 vsubs rppd w=2U l=3.43U m=1 b=0
XR147 t038__t1 t039__t0 vsubs rppd w=2U l=3.43U m=1 b=0
XR148 t052__t1 t051__t0 vsubs rppd w=2U l=3.43U m=1 b=0
XR149 t068__t1 t069__t0 vsubs rppd w=2U l=3.43U m=1 b=0
XR150 t082__t1 t081__t0 vsubs rppd w=2U l=3.43U m=1 b=0
XR151 t098__t1 t099__t0 vsubs rppd w=2U l=3.43U m=1 b=0
XR152 t112__t1 t111__t0 vsubs rppd w=2U l=3.43U m=1 b=0
XR153 t128__t1 t129__t0 vsubs rppd w=2U l=3.43U m=1 b=0
XR154 t142__t1 t141__t0 vsubs rppd w=2U l=3.43U m=1 b=0
XR155 t158__t1 t159__t0 vsubs rppd w=2U l=3.43U m=1 b=0
XR156 t172__t1 t171__t0 vsubs rppd w=2U l=3.43U m=1 b=0
XR157 t188__t1 t189__t0 vsubs rppd w=2U l=3.43U m=1 b=0
XR158 t202__t1 t201__t0 vsubs rppd w=2U l=3.43U m=1 b=0
XR159 t218__t1 t219__t0 vsubs rppd w=2U l=3.43U m=1 b=0
XR160 t232__t1 t231__t0 vsubs rppd w=2U l=3.43U m=1 b=0
XR161 t248__t1 t249__t0 vsubs rppd w=2U l=3.43U m=1 b=0
XR162 t009__t1 t010__t0 vsubs rppd w=2U l=3.43U m=1 b=0
XR163 t021__t1 t020__t0 vsubs rppd w=2U l=3.43U m=1 b=0
XR164 t039__t1 t040__t0 vsubs rppd w=2U l=3.43U m=1 b=0
XR165 t051__t1 t050__t0 vsubs rppd w=2U l=3.43U m=1 b=0
XR166 t069__t1 t070__t0 vsubs rppd w=2U l=3.43U m=1 b=0
XR167 t081__t1 t080__t0 vsubs rppd w=2U l=3.43U m=1 b=0
XR168 t099__t1 t100__t0 vsubs rppd w=2U l=3.43U m=1 b=0
XR169 t111__t1 t110__t0 vsubs rppd w=2U l=3.43U m=1 b=0
XR170 t129__t1 t130__t0 vsubs rppd w=2U l=3.43U m=1 b=0
XR171 t141__t1 t140__t0 vsubs rppd w=2U l=3.43U m=1 b=0
XR172 t159__t1 t160__t0 vsubs rppd w=2U l=3.43U m=1 b=0
XR173 t171__t1 t170__t0 vsubs rppd w=2U l=3.43U m=1 b=0
XR174 t189__t1 t190__t0 vsubs rppd w=2U l=3.43U m=1 b=0
XR175 t201__t1 t200__t0 vsubs rppd w=2U l=3.43U m=1 b=0
XR176 t219__t1 t220__t0 vsubs rppd w=2U l=3.43U m=1 b=0
XR177 t231__t1 t230__t0 vsubs rppd w=2U l=3.43U m=1 b=0
XR178 t249__t1 t250__t0 vsubs rppd w=2U l=3.43U m=1 b=0
XR179 t010__t1 t011__t0 vsubs rppd w=2U l=3.43U m=1 b=0
XR180 t020__t1 t019__t0 vsubs rppd w=2U l=3.43U m=1 b=0
XR181 t040__t1 t041__t0 vsubs rppd w=2U l=3.43U m=1 b=0
XR182 t050__t1 t049__t0 vsubs rppd w=2U l=3.43U m=1 b=0
XR183 t070__t1 t071__t0 vsubs rppd w=2U l=3.43U m=1 b=0
XR184 t080__t1 t079__t0 vsubs rppd w=2U l=3.43U m=1 b=0
XR185 t100__t1 t101__t0 vsubs rppd w=2U l=3.43U m=1 b=0
XR186 t110__t1 t109__t0 vsubs rppd w=2U l=3.43U m=1 b=0
XR187 t130__t1 t131__t0 vsubs rppd w=2U l=3.43U m=1 b=0
XR188 t140__t1 t139__t0 vsubs rppd w=2U l=3.43U m=1 b=0
XR189 t160__t1 t161__t0 vsubs rppd w=2U l=3.43U m=1 b=0
XR190 t170__t1 t169__t0 vsubs rppd w=2U l=3.43U m=1 b=0
XR191 t190__t1 t191__t0 vsubs rppd w=2U l=3.43U m=1 b=0
XR192 t200__t1 t199__t0 vsubs rppd w=2U l=3.43U m=1 b=0
XR193 t220__t1 t221__t0 vsubs rppd w=2U l=3.43U m=1 b=0
XR194 t230__t1 t229__t0 vsubs rppd w=2U l=3.43U m=1 b=0
XR195 t250__t1 t251__t0 vsubs rppd w=2U l=3.43U m=1 b=0
XR196 t011__t1 t012__t0 vsubs rppd w=2U l=3.43U m=1 b=0
XR197 t019__t1 t018__t0 vsubs rppd w=2U l=3.43U m=1 b=0
XR198 t041__t1 t042__t0 vsubs rppd w=2U l=3.43U m=1 b=0
XR199 t049__t1 t048__t0 vsubs rppd w=2U l=3.43U m=1 b=0
XR200 t071__t1 t072__t0 vsubs rppd w=2U l=3.43U m=1 b=0
XR201 t079__t1 t078__t0 vsubs rppd w=2U l=3.43U m=1 b=0
XR202 t101__t1 t102__t0 vsubs rppd w=2U l=3.43U m=1 b=0
XR203 t109__t1 t108__t0 vsubs rppd w=2U l=3.43U m=1 b=0
XR204 t131__t1 t132__t0 vsubs rppd w=2U l=3.43U m=1 b=0
XR205 t139__t1 t138__t0 vsubs rppd w=2U l=3.43U m=1 b=0
XR206 t161__t1 t162__t0 vsubs rppd w=2U l=3.43U m=1 b=0
XR207 t169__t1 t168__t0 vsubs rppd w=2U l=3.43U m=1 b=0
XR208 t191__t1 t192__t0 vsubs rppd w=2U l=3.43U m=1 b=0
XR209 t199__t1 t198__t0 vsubs rppd w=2U l=3.43U m=1 b=0
XR210 t221__t1 t222__t0 vsubs rppd w=2U l=3.43U m=1 b=0
XR211 t229__t1 t228__t0 vsubs rppd w=2U l=3.43U m=1 b=0
XR212 t251__t1 t252__t0 vsubs rppd w=2U l=3.43U m=1 b=0
XR213 t012__t1 t013__t0 vsubs rppd w=2U l=3.43U m=1 b=0
XR214 t018__t1 t017__t0 vsubs rppd w=2U l=3.43U m=1 b=0
XR215 t042__t1 t043__t0 vsubs rppd w=2U l=3.43U m=1 b=0
XR216 t048__t1 t047__t0 vsubs rppd w=2U l=3.43U m=1 b=0
XR217 t072__t1 t073__t0 vsubs rppd w=2U l=3.43U m=1 b=0
XR218 t078__t1 t077__t0 vsubs rppd w=2U l=3.43U m=1 b=0
XR219 t102__t1 t103__t0 vsubs rppd w=2U l=3.43U m=1 b=0
XR220 t108__t1 t107__t0 vsubs rppd w=2U l=3.43U m=1 b=0
XR221 t132__t1 t133__t0 vsubs rppd w=2U l=3.43U m=1 b=0
XR222 t138__t1 t137__t0 vsubs rppd w=2U l=3.43U m=1 b=0
XR223 t162__t1 t163__t0 vsubs rppd w=2U l=3.43U m=1 b=0
XR224 t168__t1 t167__t0 vsubs rppd w=2U l=3.43U m=1 b=0
XR225 t192__t1 t193__t0 vsubs rppd w=2U l=3.43U m=1 b=0
XR226 t198__t1 t197__t0 vsubs rppd w=2U l=3.43U m=1 b=0
XR227 t222__t1 t223__t0 vsubs rppd w=2U l=3.43U m=1 b=0
XR228 t228__t1 t227__t0 vsubs rppd w=2U l=3.43U m=1 b=0
XR229 t252__t1 t253__t0 vsubs rppd w=2U l=3.43U m=1 b=0
XR230 t013__t1 t014__t0 vsubs rppd w=2U l=3.43U m=1 b=0
XR231 t017__t1 t016__t0 vsubs rppd w=2U l=3.43U m=1 b=0
XR232 t043__t1 t044__t0 vsubs rppd w=2U l=3.43U m=1 b=0
XR233 t047__t1 t046__t0 vsubs rppd w=2U l=3.43U m=1 b=0
XR234 t073__t1 t074__t0 vsubs rppd w=2U l=3.43U m=1 b=0
XR235 t077__t1 t076__t0 vsubs rppd w=2U l=3.43U m=1 b=0
XR236 t103__t1 t104__t0 vsubs rppd w=2U l=3.43U m=1 b=0
XR237 t107__t1 t106__t0 vsubs rppd w=2U l=3.43U m=1 b=0
XR238 t133__t1 t134__t0 vsubs rppd w=2U l=3.43U m=1 b=0
XR239 t137__t1 t136__t0 vsubs rppd w=2U l=3.43U m=1 b=0
XR240 t163__t1 t164__t0 vsubs rppd w=2U l=3.43U m=1 b=0
XR241 t167__t1 t166__t0 vsubs rppd w=2U l=3.43U m=1 b=0
XR242 t193__t1 t194__t0 vsubs rppd w=2U l=3.43U m=1 b=0
XR243 t197__t1 t196__t0 vsubs rppd w=2U l=3.43U m=1 b=0
XR244 t223__t1 t224__t0 vsubs rppd w=2U l=3.43U m=1 b=0
XR245 t227__t1 t226__t0 vsubs rppd w=2U l=3.43U m=1 b=0
XR246 t253__t1 t254__t0 vsubs rppd w=2U l=3.43U m=1 b=0
XR247 t014__t1 tn0_merged__t3 vsubs rppd w=2U l=3.43U m=1 b=0
XR248 t016__t1 tn0_merged__t4 vsubs rppd w=2U l=3.43U m=1 b=0
XR249 t044__t1 t045__t0 vsubs rppd w=2U l=3.43U m=1 b=0
XR250 t046__t1 t045__t1 vsubs rppd w=2U l=3.43U m=1 b=0
XR251 t074__t1 t075__t0 vsubs rppd w=2U l=3.43U m=1 b=0
XR252 t076__t1 t075__t1 vsubs rppd w=2U l=3.43U m=1 b=0
XR253 t104__t1 t105__t0 vsubs rppd w=2U l=3.43U m=1 b=0
XR254 t106__t1 t105__t1 vsubs rppd w=2U l=3.43U m=1 b=0
XR255 t134__t1 t135__t0 vsubs rppd w=2U l=3.43U m=1 b=0
XR256 t136__t1 t135__t1 vsubs rppd w=2U l=3.43U m=1 b=0
XR257 t164__t1 t165__t0 vsubs rppd w=2U l=3.43U m=1 b=0
XR258 t166__t1 t165__t1 vsubs rppd w=2U l=3.43U m=1 b=0
XR259 t194__t1 t195__t0 vsubs rppd w=2U l=3.43U m=1 b=0
XR260 t196__t1 t195__t1 vsubs rppd w=2U l=3.43U m=1 b=0
XR261 t224__t1 t225__t0 vsubs rppd w=2U l=3.43U m=1 b=0
XR262 t226__t1 t225__t1 vsubs rppd w=2U l=3.43U m=1 b=0
XR263 t254__t1 cb3__t0 vsubs rppd w=2U l=3.43U m=1 b=0

* Bipolar devices -- schematic-sourced (see header).
XQ1 sns1 sns1 vss vss npn13G2 Nx=1
XQ2 cb2 cb2 vss vss npn13G2 Nx=8
XQ3 cb3 cb3 vss vss npn13G2 Nx=1

* Wire parasitics -- verbatim from the extraction, node names lowered
* and the merged tap net renamed (see header).
rcb2_t0 cb2__t0 cb2 27.8805
ccb2 cb2 vsubs 9.47633e-15
rcb3_t0 cb3__t0 cb3 39.5298
ccb3 cb3 vsubs 1.2212026e-14
rsns1_t0 sns1__t0 sns1 14.5679
csns1 sns1 vsubs 4.254508e-15
rsns2_t0 sns2__t0 sns2 2.91618268835
rsns2_t1 sns2__t1 sns2 3.24388944631
rsns2_t2 sns2__t2 sns2 4.45932786534
csns2 sns2 vsubs 3.302774e-15
rt001_t003_t007_t015_t031_t063_t127_tn0_t0 tn0_merged__t0 tn0_merged 2.11090126715
rt001_t003_t007_t015_t031_t063_t127_tn0_t1 tn0_merged__t1 tn0_merged 2.11090126715
rt001_t003_t007_t015_t031_t063_t127_tn0_t2 tn0_merged__t2 tn0_merged 3.63531948028
rt001_t003_t007_t015_t031_t063_t127_tn0_t3 tn0_merged__t3 tn0_merged 4.27061990501
rt001_t003_t007_t015_t031_t063_t127_tn0_t4 tn0_merged__t4 tn0_merged 4.26093302685
rt001_t003_t007_t015_t031_t063_t127_tn0_t5 tn0_merged__t5 tn0_merged 1.93408591204
rt001_t003_t007_t015_t031_t063_t127_tn0_t6 tn0_merged__t6 tn0_merged 2.10490493459
rt001_t003_t007_t015_t031_t063_t127_tn0_t7 tn0_merged__t7 tn0_merged 1.41201137533
rt001_t003_t007_t015_t031_t063_t127_tn0_t8 tn0_merged__t8 tn0_merged 1.21831829578
rt001_t003_t007_t015_t031_t063_t127_tn0_t9 tn0_merged__t9 tn0_merged 0.693969294669
rt001_t003_t007_t015_t031_t063_t127_tn0_t10 tn0_merged__t10 tn0_merged 2.1258606051
rt001_t003_t007_t015_t031_t063_t127_tn0_t11 tn0_merged__t11 tn0_merged 1.12258112361
rt001_t003_t007_t015_t031_t063_t127_tn0_t12 tn0_merged__t12 tn0_merged 1.65498282014
rt001_t003_t007_t015_t031_t063_t127_tn0_t13 tn0_merged__t13 tn0_merged 1.66260263169
rt001_t003_t007_t015_t031_t063_t127_tn0_t14 tn0_merged__t14 tn0_merged 1.06091314001
rt001_t003_t007_t015_t031_t063_t127_tn0_t15 tn0_merged__t15 tn0_merged 0.784894920608
ct001_t003_t007_t015_t031_t063_t127_tn0 tn0_merged vsubs 2.4956079e-14
rt002_t0 t002__t0 t002 0.0275
rt002_t1 t002__t1 t002 0.0275
ct002 t002 vsubs 3.43837e-16
rt004_t0 t004__t0 t004 0.0275
rt004_t1 t004__t1 t004 0.0275
ct004 t004 vsubs 3.43837e-16
rt005_t0 t005__t0 t005 0.0275
rt005_t1 t005__t1 t005 0.0275
ct005 t005 vsubs 3.43837e-16
rt006_t0 t006__t0 t006 0.0275
rt006_t1 t006__t1 t006 0.0275
ct006 t006 vsubs 3.43837e-16
rt008_t0 t008__t0 t008 0.0275
rt008_t1 t008__t1 t008 0.0275
ct008 t008 vsubs 3.43837e-16
rt009_t0 t009__t0 t009 0.0275
rt009_t1 t009__t1 t009 0.0275
ct009 t009 vsubs 3.43837e-16
rt010_t0 t010__t0 t010 0.0275
rt010_t1 t010__t1 t010 0.0275
ct010 t010 vsubs 3.43837e-16
rt011_t0 t011__t0 t011 0.0275
rt011_t1 t011__t1 t011 0.0275
ct011 t011 vsubs 3.43837e-16
rt012_t0 t012__t0 t012 0.0275
rt012_t1 t012__t1 t012 0.0275
ct012 t012 vsubs 3.43837e-16
rt013_t0 t013__t0 t013 0.0275
rt013_t1 t013__t1 t013 0.0275
ct013 t013 vsubs 3.43837e-16
rt014_t0 t014__t0 t014 0.0275
rt014_t1 t014__t1 t014 0.0275
ct014 t014 vsubs 3.43837e-16
rt016_t0 t016__t0 t016 0.0275
rt016_t1 t016__t1 t016 0.0275
ct016 t016 vsubs 3.85855e-16
rt017_t0 t017__t0 t017 0.0275
rt017_t1 t017__t1 t017 0.0275
ct017 t017 vsubs 3.85855e-16
rt018_t0 t018__t0 t018 0.0275
rt018_t1 t018__t1 t018 0.0275
ct018 t018 vsubs 3.85855e-16
rt019_t0 t019__t0 t019 0.0275
rt019_t1 t019__t1 t019 0.0275
ct019 t019 vsubs 3.85855e-16
rt020_t0 t020__t0 t020 0.0275
rt020_t1 t020__t1 t020 0.0275
ct020 t020 vsubs 3.85855e-16
rt021_t0 t021__t0 t021 0.0275
rt021_t1 t021__t1 t021 0.0275
ct021 t021 vsubs 3.85855e-16
rt022_t0 t022__t0 t022 0.0275
rt022_t1 t022__t1 t022 0.0275
ct022 t022 vsubs 3.85855e-16
rt023_t0 t023__t0 t023 0.0275
rt023_t1 t023__t1 t023 0.0275
ct023 t023 vsubs 3.85855e-16
rt024_t0 t024__t0 t024 0.0275
rt024_t1 t024__t1 t024 0.0275
ct024 t024 vsubs 3.85855e-16
rt025_t0 t025__t0 t025 0.0275
rt025_t1 t025__t1 t025 0.0275
ct025 t025 vsubs 3.85855e-16
rt026_t0 t026__t0 t026 0.0275
rt026_t1 t026__t1 t026 0.0275
ct026 t026 vsubs 3.85855e-16
rt027_t0 t027__t0 t027 0.0275
rt027_t1 t027__t1 t027 0.0275
ct027 t027 vsubs 3.85855e-16
rt028_t0 t028__t0 t028 0.0275
rt028_t1 t028__t1 t028 0.0275
ct028 t028 vsubs 3.85855e-16
rt029_t0 t029__t0 t029 0.0275
rt029_t1 t029__t1 t029 0.0275
ct029 t029 vsubs 3.85855e-16
rt030_t0 t030__t0 t030 0.561
rt030_t1 t030__t1 t030 0.561
ct030 t030 vsubs 5.3264e-16
rt032_t0 t032__t0 t032 0.0275
rt032_t1 t032__t1 t032 0.0275
ct032 t032 vsubs 3.43837e-16
rt033_t0 t033__t0 t033 0.0275
rt033_t1 t033__t1 t033 0.0275
ct033 t033 vsubs 3.43837e-16
rt034_t0 t034__t0 t034 0.0275
rt034_t1 t034__t1 t034 0.0275
ct034 t034 vsubs 3.43837e-16
rt035_t0 t035__t0 t035 0.0275
rt035_t1 t035__t1 t035 0.0275
ct035 t035 vsubs 3.43837e-16
rt036_t0 t036__t0 t036 0.0275
rt036_t1 t036__t1 t036 0.0275
ct036 t036 vsubs 3.43837e-16
rt037_t0 t037__t0 t037 0.0275
rt037_t1 t037__t1 t037 0.0275
ct037 t037 vsubs 3.43837e-16
rt038_t0 t038__t0 t038 0.0275
rt038_t1 t038__t1 t038 0.0275
ct038 t038 vsubs 3.43837e-16
rt039_t0 t039__t0 t039 0.0275
rt039_t1 t039__t1 t039 0.0275
ct039 t039 vsubs 3.43837e-16
rt040_t0 t040__t0 t040 0.0275
rt040_t1 t040__t1 t040 0.0275
ct040 t040 vsubs 3.43837e-16
rt041_t0 t041__t0 t041 0.0275
rt041_t1 t041__t1 t041 0.0275
ct041 t041 vsubs 3.43837e-16
rt042_t0 t042__t0 t042 0.0275
rt042_t1 t042__t1 t042 0.0275
ct042 t042 vsubs 3.43837e-16
rt043_t0 t043__t0 t043 0.0275
rt043_t1 t043__t1 t043 0.0275
ct043 t043 vsubs 3.43837e-16
rt044_t0 t044__t0 t044 0.0275
rt044_t1 t044__t1 t044 0.0275
ct044 t044 vsubs 3.43837e-16
rt045_t0 t045__t0 t045 0.561
rt045_t1 t045__t1 t045 0.561
ct045 t045 vsubs 5.07254e-16
rt046_t0 t046__t0 t046 0.0275
rt046_t1 t046__t1 t046 0.0275
ct046 t046 vsubs 3.85855e-16
rt047_t0 t047__t0 t047 0.0275
rt047_t1 t047__t1 t047 0.0275
ct047 t047 vsubs 3.85855e-16
rt048_t0 t048__t0 t048 0.0275
rt048_t1 t048__t1 t048 0.0275
ct048 t048 vsubs 3.85855e-16
rt049_t0 t049__t0 t049 0.0275
rt049_t1 t049__t1 t049 0.0275
ct049 t049 vsubs 3.85855e-16
rt050_t0 t050__t0 t050 0.0275
rt050_t1 t050__t1 t050 0.0275
ct050 t050 vsubs 3.85855e-16
rt051_t0 t051__t0 t051 0.0275
rt051_t1 t051__t1 t051 0.0275
ct051 t051 vsubs 3.85855e-16
rt052_t0 t052__t0 t052 0.0275
rt052_t1 t052__t1 t052 0.0275
ct052 t052 vsubs 3.85855e-16
rt053_t0 t053__t0 t053 0.0275
rt053_t1 t053__t1 t053 0.0275
ct053 t053 vsubs 3.85855e-16
rt054_t0 t054__t0 t054 0.0275
rt054_t1 t054__t1 t054 0.0275
ct054 t054 vsubs 3.85855e-16
rt055_t0 t055__t0 t055 0.0275
rt055_t1 t055__t1 t055 0.0275
ct055 t055 vsubs 3.85855e-16
rt056_t0 t056__t0 t056 0.0275
rt056_t1 t056__t1 t056 0.0275
ct056 t056 vsubs 3.85855e-16
rt057_t0 t057__t0 t057 0.0275
rt057_t1 t057__t1 t057 0.0275
ct057 t057 vsubs 3.85855e-16
rt058_t0 t058__t0 t058 0.0275
rt058_t1 t058__t1 t058 0.0275
ct058 t058 vsubs 3.85855e-16
rt059_t0 t059__t0 t059 0.0275
rt059_t1 t059__t1 t059 0.0275
ct059 t059 vsubs 3.22828e-16
rt060_t0 t060__t0 t060 0.561
rt060_t1 t060__t1 t060 0.561
ct060 t060 vsubs 5.3264e-16
rt061_t0 t061__t0 t061 0.0275
rt061_t1 t061__t1 t061 0.0275
ct061 t061 vsubs 3.29831e-16
rt062_t0 t062__t0 t062 0.0275
rt062_t1 t062__t1 t062 0.0275
ct062 t062 vsubs 3.43837e-16
rt064_t0 t064__t0 t064 0.0275
rt064_t1 t064__t1 t064 0.0275
ct064 t064 vsubs 3.85855e-16
rt065_t0 t065__t0 t065 0.0275
rt065_t1 t065__t1 t065 0.0275
ct065 t065 vsubs 3.85855e-16
rt066_t0 t066__t0 t066 0.0275
rt066_t1 t066__t1 t066 0.0275
ct066 t066 vsubs 3.85855e-16
rt067_t0 t067__t0 t067 0.0275
rt067_t1 t067__t1 t067 0.0275
ct067 t067 vsubs 3.85855e-16
rt068_t0 t068__t0 t068 0.0275
rt068_t1 t068__t1 t068 0.0275
ct068 t068 vsubs 3.85855e-16
rt069_t0 t069__t0 t069 0.0275
rt069_t1 t069__t1 t069 0.0275
ct069 t069 vsubs 3.85855e-16
rt070_t0 t070__t0 t070 0.0275
rt070_t1 t070__t1 t070 0.0275
ct070 t070 vsubs 3.85855e-16
rt071_t0 t071__t0 t071 0.0275
rt071_t1 t071__t1 t071 0.0275
ct071 t071 vsubs 3.85855e-16
rt072_t0 t072__t0 t072 0.0275
rt072_t1 t072__t1 t072 0.0275
ct072 t072 vsubs 3.85855e-16
rt073_t0 t073__t0 t073 0.0275
rt073_t1 t073__t1 t073 0.0275
ct073 t073 vsubs 3.85855e-16
rt074_t0 t074__t0 t074 0.0275
rt074_t1 t074__t1 t074 0.0275
ct074 t074 vsubs 3.85855e-16
rt075_t0 t075__t0 t075 0.561
rt075_t1 t075__t1 t075 0.561
ct075 t075 vsubs 5.3264e-16
rt076_t0 t076__t0 t076 0.0275
rt076_t1 t076__t1 t076 0.0275
ct076 t076 vsubs 3.85855e-16
rt077_t0 t077__t0 t077 0.0275
rt077_t1 t077__t1 t077 0.0275
ct077 t077 vsubs 3.85855e-16
rt078_t0 t078__t0 t078 0.0275
rt078_t1 t078__t1 t078 0.0275
ct078 t078 vsubs 3.85855e-16
rt079_t0 t079__t0 t079 0.0275
rt079_t1 t079__t1 t079 0.0275
ct079 t079 vsubs 3.85855e-16
rt080_t0 t080__t0 t080 0.0275
rt080_t1 t080__t1 t080 0.0275
ct080 t080 vsubs 3.85855e-16
rt081_t0 t081__t0 t081 0.0275
rt081_t1 t081__t1 t081 0.0275
ct081 t081 vsubs 3.85855e-16
rt082_t0 t082__t0 t082 0.0275
rt082_t1 t082__t1 t082 0.0275
ct082 t082 vsubs 3.85855e-16
rt083_t0 t083__t0 t083 0.0275
rt083_t1 t083__t1 t083 0.0275
ct083 t083 vsubs 3.85855e-16
rt084_t0 t084__t0 t084 0.0275
rt084_t1 t084__t1 t084 0.0275
ct084 t084 vsubs 3.85855e-16
rt085_t0 t085__t0 t085 0.0275
rt085_t1 t085__t1 t085 0.0275
ct085 t085 vsubs 3.85855e-16
rt086_t0 t086__t0 t086 0.0275
rt086_t1 t086__t1 t086 0.0275
ct086 t086 vsubs 3.85855e-16
rt087_t0 t087__t0 t087 0.0275
rt087_t1 t087__t1 t087 0.0275
ct087 t087 vsubs 3.22828e-16
rt088_t0 t088__t0 t088 0.0275
rt088_t1 t088__t1 t088 0.0275
ct088 t088 vsubs 3.85855e-16
rt089_t0 t089__t0 t089 0.0275
rt089_t1 t089__t1 t089 0.0275
ct089 t089 vsubs 3.85855e-16
rt090_t0 t090__t0 t090 0.561
rt090_t1 t090__t1 t090 0.561
ct090 t090 vsubs 5.3264e-16
rt091_t0 t091__t0 t091 0.0275
rt091_t1 t091__t1 t091 0.0275
ct091 t091 vsubs 3.85855e-16
rt092_t0 t092__t0 t092 0.0275
rt092_t1 t092__t1 t092 0.0275
ct092 t092 vsubs 3.85855e-16
rt093_t0 t093__t0 t093 0.0275
rt093_t1 t093__t1 t093 0.0275
ct093 t093 vsubs 3.22828e-16
rt094_t0 t094__t0 t094 0.0275
rt094_t1 t094__t1 t094 0.0275
ct094 t094 vsubs 3.85855e-16
rt095_t0 t095__t0 t095 0.0275
rt095_t1 t095__t1 t095 0.0275
ct095 t095 vsubs 3.85855e-16
rt096_t0 t096__t0 t096 0.0275
rt096_t1 t096__t1 t096 0.0275
ct096 t096 vsubs 3.85855e-16
rt097_t0 t097__t0 t097 0.0275
rt097_t1 t097__t1 t097 0.0275
ct097 t097 vsubs 3.85855e-16
rt098_t0 t098__t0 t098 0.0275
rt098_t1 t098__t1 t098 0.0275
ct098 t098 vsubs 3.85855e-16
rt099_t0 t099__t0 t099 0.0275
rt099_t1 t099__t1 t099 0.0275
ct099 t099 vsubs 3.85855e-16
rt100_t0 t100__t0 t100 0.0275
rt100_t1 t100__t1 t100 0.0275
ct100 t100 vsubs 3.85855e-16
rt101_t0 t101__t0 t101 0.0275
rt101_t1 t101__t1 t101 0.0275
ct101 t101 vsubs 3.85855e-16
rt102_t0 t102__t0 t102 0.0275
rt102_t1 t102__t1 t102 0.0275
ct102 t102 vsubs 3.85855e-16
rt103_t0 t103__t0 t103 0.0275
rt103_t1 t103__t1 t103 0.0275
ct103 t103 vsubs 3.85855e-16
rt104_t0 t104__t0 t104 0.0275
rt104_t1 t104__t1 t104 0.0275
ct104 t104 vsubs 3.85855e-16
rt105_t0 t105__t0 t105 0.561
rt105_t1 t105__t1 t105 0.561
ct105 t105 vsubs 5.3264e-16
rt106_t0 t106__t0 t106 0.0275
rt106_t1 t106__t1 t106 0.0275
ct106 t106 vsubs 3.85855e-16
rt107_t0 t107__t0 t107 0.0275
rt107_t1 t107__t1 t107 0.0275
ct107 t107 vsubs 3.85855e-16
rt108_t0 t108__t0 t108 0.0275
rt108_t1 t108__t1 t108 0.0275
ct108 t108 vsubs 3.85855e-16
rt109_t0 t109__t0 t109 0.0275
rt109_t1 t109__t1 t109 0.0275
ct109 t109 vsubs 3.85855e-16
rt110_t0 t110__t0 t110 0.0275
rt110_t1 t110__t1 t110 0.0275
ct110 t110 vsubs 3.85855e-16
rt111_t0 t111__t0 t111 0.0275
rt111_t1 t111__t1 t111 0.0275
ct111 t111 vsubs 3.85855e-16
rt112_t0 t112__t0 t112 0.0275
rt112_t1 t112__t1 t112 0.0275
ct112 t112 vsubs 3.85855e-16
rt113_t0 t113__t0 t113 0.0275
rt113_t1 t113__t1 t113 0.0275
ct113 t113 vsubs 3.85855e-16
rt114_t0 t114__t0 t114 0.0275
rt114_t1 t114__t1 t114 0.0275
ct114 t114 vsubs 3.85855e-16
rt115_t0 t115__t0 t115 0.0275
rt115_t1 t115__t1 t115 0.0275
ct115 t115 vsubs 3.85855e-16
rt116_t0 t116__t0 t116 0.0275
rt116_t1 t116__t1 t116 0.0275
ct116 t116 vsubs 3.85855e-16
rt117_t0 t117__t0 t117 0.0275
rt117_t1 t117__t1 t117 0.0275
ct117 t117 vsubs 3.22828e-16
rt118_t0 t118__t0 t118 0.0275
rt118_t1 t118__t1 t118 0.0275
ct118 t118 vsubs 3.85855e-16
rt119_t0 t119__t0 t119 0.0275
rt119_t1 t119__t1 t119 0.0275
ct119 t119 vsubs 3.85855e-16
rt120_t0 t120__t0 t120 0.561
rt120_t1 t120__t1 t120 0.561
ct120 t120 vsubs 5.3264e-16
rt121_t0 t121__t0 t121 0.0275
rt121_t1 t121__t1 t121 0.0275
ct121 t121 vsubs 3.85855e-16
rt122_t0 t122__t0 t122 0.0275
rt122_t1 t122__t1 t122 0.0275
ct122 t122 vsubs 3.85855e-16
rt123_t0 t123__t0 t123 0.0275
rt123_t1 t123__t1 t123 0.0275
ct123 t123 vsubs 3.29831e-16
rt124_t0 t124__t0 t124 0.0275
rt124_t1 t124__t1 t124 0.0275
ct124 t124 vsubs 3.43837e-16
rt125_t0 t125__t0 t125 0.0275
rt125_t1 t125__t1 t125 0.0275
ct125 t125 vsubs 3.43837e-16
rt126_t0 t126__t0 t126 0.0275
rt126_t1 t126__t1 t126 0.0275
ct126 t126 vsubs 3.43837e-16
rt128_t0 t128__t0 t128 0.0275
rt128_t1 t128__t1 t128 0.0275
ct128 t128 vsubs 3.85855e-16
rt129_t0 t129__t0 t129 0.0275
rt129_t1 t129__t1 t129 0.0275
ct129 t129 vsubs 3.85855e-16
rt130_t0 t130__t0 t130 0.0275
rt130_t1 t130__t1 t130 0.0275
ct130 t130 vsubs 3.85855e-16
rt131_t0 t131__t0 t131 0.0275
rt131_t1 t131__t1 t131 0.0275
ct131 t131 vsubs 3.85855e-16
rt132_t0 t132__t0 t132 0.0275
rt132_t1 t132__t1 t132 0.0275
ct132 t132 vsubs 3.85855e-16
rt133_t0 t133__t0 t133 0.0275
rt133_t1 t133__t1 t133 0.0275
ct133 t133 vsubs 3.85855e-16
rt134_t0 t134__t0 t134 0.0275
rt134_t1 t134__t1 t134 0.0275
ct134 t134 vsubs 3.85855e-16
rt135_t0 t135__t0 t135 0.561
rt135_t1 t135__t1 t135 0.561
ct135 t135 vsubs 5.3264e-16
rt136_t0 t136__t0 t136 0.0275
rt136_t1 t136__t1 t136 0.0275
ct136 t136 vsubs 3.85855e-16
rt137_t0 t137__t0 t137 0.0275
rt137_t1 t137__t1 t137 0.0275
ct137 t137 vsubs 3.85855e-16
rt138_t0 t138__t0 t138 0.0275
rt138_t1 t138__t1 t138 0.0275
ct138 t138 vsubs 3.85855e-16
rt139_t0 t139__t0 t139 0.0275
rt139_t1 t139__t1 t139 0.0275
ct139 t139 vsubs 3.85855e-16
rt140_t0 t140__t0 t140 0.0275
rt140_t1 t140__t1 t140 0.0275
ct140 t140 vsubs 3.85855e-16
rt141_t0 t141__t0 t141 0.0275
rt141_t1 t141__t1 t141 0.0275
ct141 t141 vsubs 3.85855e-16
rt142_t0 t142__t0 t142 0.0275
rt142_t1 t142__t1 t142 0.0275
ct142 t142 vsubs 3.85855e-16
rt143_t0 t143__t0 t143 0.0275
rt143_t1 t143__t1 t143 0.0275
ct143 t143 vsubs 3.85855e-16
rt144_t0 t144__t0 t144 0.0275
rt144_t1 t144__t1 t144 0.0275
ct144 t144 vsubs 3.85855e-16
rt145_t0 t145__t0 t145 0.0275
rt145_t1 t145__t1 t145 0.0275
ct145 t145 vsubs 3.85855e-16
rt146_t0 t146__t0 t146 0.0275
rt146_t1 t146__t1 t146 0.0275
ct146 t146 vsubs 3.85855e-16
rt147_t0 t147__t0 t147 0.0275
rt147_t1 t147__t1 t147 0.0275
ct147 t147 vsubs 3.85855e-16
rt148_t0 t148__t0 t148 0.0275
rt148_t1 t148__t1 t148 0.0275
ct148 t148 vsubs 3.85855e-16
rt149_t0 t149__t0 t149 0.0275
rt149_t1 t149__t1 t149 0.0275
ct149 t149 vsubs 3.85855e-16
rt150_t0 t150__t0 t150 0.561
rt150_t1 t150__t1 t150 0.561
ct150 t150 vsubs 5.3264e-16
rt151_t0 t151__t0 t151 0.0275
rt151_t1 t151__t1 t151 0.0275
ct151 t151 vsubs 3.85855e-16
rt152_t0 t152__t0 t152 0.0275
rt152_t1 t152__t1 t152 0.0275
ct152 t152 vsubs 3.85855e-16
rt153_t0 t153__t0 t153 0.0275
rt153_t1 t153__t1 t153 0.0275
ct153 t153 vsubs 3.85855e-16
rt154_t0 t154__t0 t154 0.0275
rt154_t1 t154__t1 t154 0.0275
ct154 t154 vsubs 3.85855e-16
rt155_t0 t155__t0 t155 0.0275
rt155_t1 t155__t1 t155 0.0275
ct155 t155 vsubs 3.85855e-16
rt156_t0 t156__t0 t156 0.0275
rt156_t1 t156__t1 t156 0.0275
ct156 t156 vsubs 3.85855e-16
rt157_t0 t157__t0 t157 0.0275
rt157_t1 t157__t1 t157 0.0275
ct157 t157 vsubs 3.85855e-16
rt158_t0 t158__t0 t158 0.0275
rt158_t1 t158__t1 t158 0.0275
ct158 t158 vsubs 3.85855e-16
rt159_t0 t159__t0 t159 0.0275
rt159_t1 t159__t1 t159 0.0275
ct159 t159 vsubs 3.85855e-16
rt160_t0 t160__t0 t160 0.0275
rt160_t1 t160__t1 t160 0.0275
ct160 t160 vsubs 3.85855e-16
rt161_t0 t161__t0 t161 0.0275
rt161_t1 t161__t1 t161 0.0275
ct161 t161 vsubs 3.85855e-16
rt162_t0 t162__t0 t162 0.0275
rt162_t1 t162__t1 t162 0.0275
ct162 t162 vsubs 3.85855e-16
rt163_t0 t163__t0 t163 0.0275
rt163_t1 t163__t1 t163 0.0275
ct163 t163 vsubs 3.85855e-16
rt164_t0 t164__t0 t164 0.0275
rt164_t1 t164__t1 t164 0.0275
ct164 t164 vsubs 3.85855e-16
rt165_t0 t165__t0 t165 0.561
rt165_t1 t165__t1 t165 0.561
ct165 t165 vsubs 5.3264e-16
rt166_t0 t166__t0 t166 0.0275
rt166_t1 t166__t1 t166 0.0275
ct166 t166 vsubs 3.85855e-16
rt167_t0 t167__t0 t167 0.0275
rt167_t1 t167__t1 t167 0.0275
ct167 t167 vsubs 3.85855e-16
rt168_t0 t168__t0 t168 0.0275
rt168_t1 t168__t1 t168 0.0275
ct168 t168 vsubs 3.85855e-16
rt169_t0 t169__t0 t169 0.0275
rt169_t1 t169__t1 t169 0.0275
ct169 t169 vsubs 3.85855e-16
rt170_t0 t170__t0 t170 0.0275
rt170_t1 t170__t1 t170 0.0275
ct170 t170 vsubs 3.85855e-16
rt171_t0 t171__t0 t171 0.0275
rt171_t1 t171__t1 t171 0.0275
ct171 t171 vsubs 3.85855e-16
rt172_t0 t172__t0 t172 0.0275
rt172_t1 t172__t1 t172 0.0275
ct172 t172 vsubs 3.85855e-16
rt173_t0 t173__t0 t173 0.0275
rt173_t1 t173__t1 t173 0.0275
ct173 t173 vsubs 3.85855e-16
rt174_t0 t174__t0 t174 0.0275
rt174_t1 t174__t1 t174 0.0275
ct174 t174 vsubs 3.85855e-16
rt175_t0 t175__t0 t175 0.0275
rt175_t1 t175__t1 t175 0.0275
ct175 t175 vsubs 3.85855e-16
rt176_t0 t176__t0 t176 0.0275
rt176_t1 t176__t1 t176 0.0275
ct176 t176 vsubs 3.85855e-16
rt177_t0 t177__t0 t177 0.0275
rt177_t1 t177__t1 t177 0.0275
ct177 t177 vsubs 3.85855e-16
rt178_t0 t178__t0 t178 0.0275
rt178_t1 t178__t1 t178 0.0275
ct178 t178 vsubs 3.85855e-16
rt179_t0 t179__t0 t179 0.0275
rt179_t1 t179__t1 t179 0.0275
ct179 t179 vsubs 3.85855e-16
rt180_t0 t180__t0 t180 0.561
rt180_t1 t180__t1 t180 0.561
ct180 t180 vsubs 5.3264e-16
rt181_t0 t181__t0 t181 0.0275
rt181_t1 t181__t1 t181 0.0275
ct181 t181 vsubs 3.85855e-16
rt182_t0 t182__t0 t182 0.0275
rt182_t1 t182__t1 t182 0.0275
ct182 t182 vsubs 3.85855e-16
rt183_t0 t183__t0 t183 0.0275
rt183_t1 t183__t1 t183 0.0275
ct183 t183 vsubs 3.85855e-16
rt184_t0 t184__t0 t184 0.0275
rt184_t1 t184__t1 t184 0.0275
ct184 t184 vsubs 3.85855e-16
rt185_t0 t185__t0 t185 0.0275
rt185_t1 t185__t1 t185 0.0275
ct185 t185 vsubs 3.85855e-16
rt186_t0 t186__t0 t186 0.0275
rt186_t1 t186__t1 t186 0.0275
ct186 t186 vsubs 3.85855e-16
rt187_t0 t187__t0 t187 0.0275
rt187_t1 t187__t1 t187 0.0275
ct187 t187 vsubs 3.85855e-16
rt188_t0 t188__t0 t188 0.0275
rt188_t1 t188__t1 t188 0.0275
ct188 t188 vsubs 3.85855e-16
rt189_t0 t189__t0 t189 0.0275
rt189_t1 t189__t1 t189 0.0275
ct189 t189 vsubs 3.85855e-16
rt190_t0 t190__t0 t190 0.0275
rt190_t1 t190__t1 t190 0.0275
ct190 t190 vsubs 3.85855e-16
rt191_t0 t191__t0 t191 0.0275
rt191_t1 t191__t1 t191 0.0275
ct191 t191 vsubs 3.85855e-16
rt192_t0 t192__t0 t192 0.0275
rt192_t1 t192__t1 t192 0.0275
ct192 t192 vsubs 3.85855e-16
rt193_t0 t193__t0 t193 0.0275
rt193_t1 t193__t1 t193 0.0275
ct193 t193 vsubs 3.85855e-16
rt194_t0 t194__t0 t194 0.0275
rt194_t1 t194__t1 t194 0.0275
ct194 t194 vsubs 3.85855e-16
rt195_t0 t195__t0 t195 0.561
rt195_t1 t195__t1 t195 0.561
ct195 t195 vsubs 5.3264e-16
rt196_t0 t196__t0 t196 0.0275
rt196_t1 t196__t1 t196 0.0275
ct196 t196 vsubs 3.85855e-16
rt197_t0 t197__t0 t197 0.0275
rt197_t1 t197__t1 t197 0.0275
ct197 t197 vsubs 3.85855e-16
rt198_t0 t198__t0 t198 0.0275
rt198_t1 t198__t1 t198 0.0275
ct198 t198 vsubs 3.85855e-16
rt199_t0 t199__t0 t199 0.0275
rt199_t1 t199__t1 t199 0.0275
ct199 t199 vsubs 3.85855e-16
rt200_t0 t200__t0 t200 0.0275
rt200_t1 t200__t1 t200 0.0275
ct200 t200 vsubs 3.85855e-16
rt201_t0 t201__t0 t201 0.0275
rt201_t1 t201__t1 t201 0.0275
ct201 t201 vsubs 3.85855e-16
rt202_t0 t202__t0 t202 0.0275
rt202_t1 t202__t1 t202 0.0275
ct202 t202 vsubs 3.85855e-16
rt203_t0 t203__t0 t203 0.0275
rt203_t1 t203__t1 t203 0.0275
ct203 t203 vsubs 3.85855e-16
rt204_t0 t204__t0 t204 0.0275
rt204_t1 t204__t1 t204 0.0275
ct204 t204 vsubs 3.85855e-16
rt205_t0 t205__t0 t205 0.0275
rt205_t1 t205__t1 t205 0.0275
ct205 t205 vsubs 3.85855e-16
rt206_t0 t206__t0 t206 0.0275
rt206_t1 t206__t1 t206 0.0275
ct206 t206 vsubs 3.85855e-16
rt207_t0 t207__t0 t207 0.0275
rt207_t1 t207__t1 t207 0.0275
ct207 t207 vsubs 3.85855e-16
rt208_t0 t208__t0 t208 0.0275
rt208_t1 t208__t1 t208 0.0275
ct208 t208 vsubs 3.85855e-16
rt209_t0 t209__t0 t209 0.0275
rt209_t1 t209__t1 t209 0.0275
ct209 t209 vsubs 3.85855e-16
rt210_t0 t210__t0 t210 0.561
rt210_t1 t210__t1 t210 0.561
ct210 t210 vsubs 5.3264e-16
rt211_t0 t211__t0 t211 0.0275
rt211_t1 t211__t1 t211 0.0275
ct211 t211 vsubs 3.85855e-16
rt212_t0 t212__t0 t212 0.0275
rt212_t1 t212__t1 t212 0.0275
ct212 t212 vsubs 3.85855e-16
rt213_t0 t213__t0 t213 0.0275
rt213_t1 t213__t1 t213 0.0275
ct213 t213 vsubs 3.85855e-16
rt214_t0 t214__t0 t214 0.0275
rt214_t1 t214__t1 t214 0.0275
ct214 t214 vsubs 3.85855e-16
rt215_t0 t215__t0 t215 0.0275
rt215_t1 t215__t1 t215 0.0275
ct215 t215 vsubs 3.85855e-16
rt216_t0 t216__t0 t216 0.0275
rt216_t1 t216__t1 t216 0.0275
ct216 t216 vsubs 3.85855e-16
rt217_t0 t217__t0 t217 0.0275
rt217_t1 t217__t1 t217 0.0275
ct217 t217 vsubs 3.85855e-16
rt218_t0 t218__t0 t218 0.0275
rt218_t1 t218__t1 t218 0.0275
ct218 t218 vsubs 3.85855e-16
rt219_t0 t219__t0 t219 0.0275
rt219_t1 t219__t1 t219 0.0275
ct219 t219 vsubs 3.85855e-16
rt220_t0 t220__t0 t220 0.0275
rt220_t1 t220__t1 t220 0.0275
ct220 t220 vsubs 3.85855e-16
rt221_t0 t221__t0 t221 0.0275
rt221_t1 t221__t1 t221 0.0275
ct221 t221 vsubs 3.85855e-16
rt222_t0 t222__t0 t222 0.0275
rt222_t1 t222__t1 t222 0.0275
ct222 t222 vsubs 3.85855e-16
rt223_t0 t223__t0 t223 0.0275
rt223_t1 t223__t1 t223 0.0275
ct223 t223 vsubs 3.85855e-16
rt224_t0 t224__t0 t224 0.0275
rt224_t1 t224__t1 t224 0.0275
ct224 t224 vsubs 3.85855e-16
rt225_t0 t225__t0 t225 0.561
rt225_t1 t225__t1 t225 0.561
ct225 t225 vsubs 5.3264e-16
rt226_t0 t226__t0 t226 0.0275
rt226_t1 t226__t1 t226 0.0275
ct226 t226 vsubs 3.85855e-16
rt227_t0 t227__t0 t227 0.0275
rt227_t1 t227__t1 t227 0.0275
ct227 t227 vsubs 3.85855e-16
rt228_t0 t228__t0 t228 0.0275
rt228_t1 t228__t1 t228 0.0275
ct228 t228 vsubs 3.85855e-16
rt229_t0 t229__t0 t229 0.0275
rt229_t1 t229__t1 t229 0.0275
ct229 t229 vsubs 3.85855e-16
rt230_t0 t230__t0 t230 0.0275
rt230_t1 t230__t1 t230 0.0275
ct230 t230 vsubs 3.85855e-16
rt231_t0 t231__t0 t231 0.0275
rt231_t1 t231__t1 t231 0.0275
ct231 t231 vsubs 3.85855e-16
rt232_t0 t232__t0 t232 0.0275
rt232_t1 t232__t1 t232 0.0275
ct232 t232 vsubs 3.85855e-16
rt233_t0 t233__t0 t233 0.0275
rt233_t1 t233__t1 t233 0.0275
ct233 t233 vsubs 3.85855e-16
rt234_t0 t234__t0 t234 0.0275
rt234_t1 t234__t1 t234 0.0275
ct234 t234 vsubs 3.85855e-16
rt235_t0 t235__t0 t235 0.0275
rt235_t1 t235__t1 t235 0.0275
ct235 t235 vsubs 3.85855e-16
rt236_t0 t236__t0 t236 0.0275
rt236_t1 t236__t1 t236 0.0275
ct236 t236 vsubs 3.85855e-16
rt237_t0 t237__t0 t237 0.0275
rt237_t1 t237__t1 t237 0.0275
ct237 t237 vsubs 3.85855e-16
rt238_t0 t238__t0 t238 0.0275
rt238_t1 t238__t1 t238 0.0275
ct238 t238 vsubs 3.85855e-16
rt239_t0 t239__t0 t239 0.0275
rt239_t1 t239__t1 t239 0.0275
ct239 t239 vsubs 3.85855e-16
rt240_t0 t240__t0 t240 0.561
rt240_t1 t240__t1 t240 0.561
ct240 t240 vsubs 5.3264e-16
rt241_t0 t241__t0 t241 0.0275
rt241_t1 t241__t1 t241 0.0275
ct241 t241 vsubs 3.85855e-16
rt242_t0 t242__t0 t242 0.0275
rt242_t1 t242__t1 t242 0.0275
ct242 t242 vsubs 3.85855e-16
rt243_t0 t243__t0 t243 0.0275
rt243_t1 t243__t1 t243 0.0275
ct243 t243 vsubs 3.85855e-16
rt244_t0 t244__t0 t244 0.0275
rt244_t1 t244__t1 t244 0.0275
ct244 t244 vsubs 3.85855e-16
rt245_t0 t245__t0 t245 0.0275
rt245_t1 t245__t1 t245 0.0275
ct245 t245 vsubs 3.85855e-16
rt246_t0 t246__t0 t246 0.0275
rt246_t1 t246__t1 t246 0.0275
ct246 t246 vsubs 3.85855e-16
rt247_t0 t247__t0 t247 0.0275
rt247_t1 t247__t1 t247 0.0275
ct247 t247 vsubs 3.85855e-16
rt248_t0 t248__t0 t248 0.0275
rt248_t1 t248__t1 t248 0.0275
ct248 t248 vsubs 3.85855e-16
rt249_t0 t249__t0 t249 0.0275
rt249_t1 t249__t1 t249 0.0275
ct249 t249 vsubs 3.85855e-16
rt250_t0 t250__t0 t250 0.0275
rt250_t1 t250__t1 t250 0.0275
ct250 t250 vsubs 3.85855e-16
rt251_t0 t251__t0 t251 0.0275
rt251_t1 t251__t1 t251 0.0275
ct251 t251 vsubs 3.85855e-16
rt252_t0 t252__t0 t252 0.0275
rt252_t1 t252__t1 t252 0.0275
ct252 t252 vsubs 3.85855e-16
rt253_t0 t253__t0 t253 0.0275
rt253_t1 t253__t1 t253 0.0275
ct253 t253 vsubs 3.85855e-16
rt254_t0 t254__t0 t254 0.0275
rt254_t1 t254__t1 t254 0.0275
ct254 t254 vsubs 3.85855e-16
rvdd_t0 vdd__t0 vdd 6.75282045455
rvdd_t1 vdd__t1 vdd 6.75282045455
rvdd_t2 vdd__t2 vdd 2.8569625
rvdd_t3 vdd__t3 vdd 2.8569625
rvdd_t4 vdd__t4 vdd 1.81806704545
rvdd_t5 vdd__t5 vdd 1.81806704545
rvdd_t6 vdd__t6 vdd 2.77038787879
rvdd_t7 vdd__t7 vdd 2.77038787879
rvdd_t8 vdd__t8 vdd 3.80928333333
rvdd_t9 vdd__t9 vdd 4.84817878788
rvdd_t10 vdd__t10 vdd 3.80928333333
rvdd_t11 vdd__t11 vdd 4.84817878788
cvdd vdd vsubs 1.314593e-14
rvref_t0 vref__t0 vref 3.58499902552
rvref_t1 vref__t1 vref 5.4477294688
rvref_t2 vref__t2 vref 1.81590982293
rvref_t3 vref__t3 vref 5.71046168275
cvref vref vsubs 5.052496e-15
rvss vss vss__par 7.5152
cvss vss__par vsubs 1.2362944e-14
ccc_cb2_vdd cb2 vdd 8.235e-18
ccc_cb2_vss cb2 vss__par 4.33601e-16
ccc_cb3_t001_t003_t007_t015_t031_t063_t127_tn0 cb3 tn0_merged 1.1764e-17
ccc_cb3_vdd cb3 vdd 8.235e-18
ccc_cb3_vref cb3 vref 8.235e-18
ccc_cb3_vss cb3 vss__par 7.0586e-17
ccc_sns1_vss sns1 vss__par 5.0419e-17
ccc_sns2_vdd sns2 vdd 8.235e-18
ccc_t001_t003_t007_t015_t031_t063_t127_tn0_t002 tn0_merged t002 8.067e-17
ccc_t001_t003_t007_t015_t031_t063_t127_tn0_t004 tn0_merged t004 8.067e-17
ccc_t001_t003_t007_t015_t031_t063_t127_tn0_t005 tn0_merged t005 8.067e-17
ccc_t001_t003_t007_t015_t031_t063_t127_tn0_t006 tn0_merged t006 8.067e-17
ccc_t001_t003_t007_t015_t031_t063_t127_tn0_t008 tn0_merged t008 8.067e-17
ccc_t001_t003_t007_t015_t031_t063_t127_tn0_t009 tn0_merged t009 8.067e-17
ccc_t001_t003_t007_t015_t031_t063_t127_tn0_t010 tn0_merged t010 8.067e-17
ccc_t001_t003_t007_t015_t031_t063_t127_tn0_t011 tn0_merged t011 8.067e-17
ccc_t001_t003_t007_t015_t031_t063_t127_tn0_t012 tn0_merged t012 8.067e-17
ccc_t001_t003_t007_t015_t031_t063_t127_tn0_t013 tn0_merged t013 8.067e-17
ccc_t001_t003_t007_t015_t031_t063_t127_tn0_t014 tn0_merged t014 8.067e-17
ccc_t001_t003_t007_t015_t031_t063_t127_tn0_t032 tn0_merged t032 8.067e-17
ccc_t001_t003_t007_t015_t031_t063_t127_tn0_t033 tn0_merged t033 8.067e-17
ccc_t001_t003_t007_t015_t031_t063_t127_tn0_t034 tn0_merged t034 8.067e-17
ccc_t001_t003_t007_t015_t031_t063_t127_tn0_t035 tn0_merged t035 8.067e-17
ccc_t001_t003_t007_t015_t031_t063_t127_tn0_t036 tn0_merged t036 8.067e-17
ccc_t001_t003_t007_t015_t031_t063_t127_tn0_t037 tn0_merged t037 8.067e-17
ccc_t001_t003_t007_t015_t031_t063_t127_tn0_t038 tn0_merged t038 8.067e-17
ccc_t001_t003_t007_t015_t031_t063_t127_tn0_t039 tn0_merged t039 8.067e-17
ccc_t001_t003_t007_t015_t031_t063_t127_tn0_t040 tn0_merged t040 8.067e-17
ccc_t001_t003_t007_t015_t031_t063_t127_tn0_t041 tn0_merged t041 8.067e-17
ccc_t001_t003_t007_t015_t031_t063_t127_tn0_t042 tn0_merged t042 8.067e-17
ccc_t001_t003_t007_t015_t031_t063_t127_tn0_t043 tn0_merged t043 8.067e-17
ccc_t001_t003_t007_t015_t031_t063_t127_tn0_t044 tn0_merged t044 8.067e-17
ccc_t001_t003_t007_t015_t031_t063_t127_tn0_t045 tn0_merged t045 4.8738e-17
ccc_t001_t003_t007_t015_t031_t063_t127_tn0_t059 tn0_merged t059 1.21005e-16
ccc_t001_t003_t007_t015_t031_t063_t127_tn0_t061 tn0_merged t061 1.0756e-16
ccc_t001_t003_t007_t015_t031_t063_t127_tn0_t062 tn0_merged t062 8.067e-17
ccc_t001_t003_t007_t015_t031_t063_t127_tn0_t087 tn0_merged t087 1.21005e-16
ccc_t001_t003_t007_t015_t031_t063_t127_tn0_t093 tn0_merged t093 1.21005e-16
ccc_t001_t003_t007_t015_t031_t063_t127_tn0_t117 tn0_merged t117 1.21005e-16
ccc_t001_t003_t007_t015_t031_t063_t127_tn0_t123 tn0_merged t123 1.0756e-16
ccc_t001_t003_t007_t015_t031_t063_t127_tn0_t124 tn0_merged t124 8.067e-17
ccc_t001_t003_t007_t015_t031_t063_t127_tn0_t125 tn0_merged t125 8.067e-17
ccc_t001_t003_t007_t015_t031_t063_t127_tn0_t126 tn0_merged t126 8.067e-17
ccc_vdd_vref vdd vref 8.235e-18
rvsubs_dctie vsubs 0 1e+12

.op
.control
pre_osdi @OSDI@/psp103.osdi
pre_osdi @OSDI@/psp103_nqs.osdi
pre_osdi @OSDI@/mosvar.osdi
pre_osdi @OSDI@/r3_cmc.osdi
run
* vref/tn0/cb3 give the summing resistor's two halves separately, which
* is what lets the ladder be measured as a unit count rather than
* trusted from the drawn geometry (see layout/README.md).
print v(vref) v(fb) v(sns1) v(sns2) v(cb2) v(cb3)
print v(tn0_merged)
print i(vm1) i(vm2) i(vm3) i(vm4) i(vm5) i(vm6)
.endc
.end
